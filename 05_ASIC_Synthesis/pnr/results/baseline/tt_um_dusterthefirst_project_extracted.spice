* NGSPICE file created from tt_um_dusterthefirst_project.ext - technology: sky130A

.subckt sky130_fd_sc_hd__dfrtp_1 VGND VPWR VPB VNB CLK D RESET_B Q
X0 a_1217_47# a_27_47# a_1108_47# VNB sky130_fd_pr__nfet_01v8 ad=0.0669 pd=0.75 as=0.0711 ps=0.755 w=0.36 l=0.15
X1 a_805_47# a_761_289# a_639_47# VNB sky130_fd_pr__nfet_01v8 ad=0.0441 pd=0.63 as=0.1401 ps=1.1 w=0.42 l=0.15
X2 a_1108_47# a_193_47# a_761_289# VNB sky130_fd_pr__nfet_01v8 ad=0.0711 pd=0.755 as=0.0999 ps=0.985 w=0.36 l=0.15
X3 a_1283_21# a_1108_47# a_1462_47# VNB sky130_fd_pr__nfet_01v8 ad=0.1092 pd=1.36 as=0.06405 ps=0.725 w=0.42 l=0.15
X4 a_651_413# a_27_47# a_543_47# VPB sky130_fd_pr__pfet_01v8_hvt ad=0.1155 pd=0.97 as=0.07245 ps=0.765 w=0.42 l=0.15
X5 VGND RESET_B a_805_47# VNB sky130_fd_pr__nfet_01v8 ad=0.1346 pd=1.15 as=0.0441 ps=0.63 w=0.42 l=0.15
X6 Q a_1283_21# VPWR VPB sky130_fd_pr__pfet_01v8_hvt ad=0.26 pd=2.52 as=0.3012 ps=2.66 w=1 l=0.15
X7 VPWR CLK a_27_47# VPB sky130_fd_pr__pfet_01v8_hvt ad=0.0864 pd=0.91 as=0.1664 ps=1.8 w=0.64 l=0.15
X8 a_448_47# D VPWR VPB sky130_fd_pr__pfet_01v8_hvt ad=0.0651 pd=0.73 as=0.1092 ps=1.36 w=0.42 l=0.15
X9 a_761_289# a_543_47# VGND VNB sky130_fd_pr__nfet_01v8 ad=0.0999 pd=0.985 as=0.1346 ps=1.15 w=0.64 l=0.15
X10 a_193_47# a_27_47# VGND VNB sky130_fd_pr__nfet_01v8 ad=0.1092 pd=1.36 as=0.0567 ps=0.69 w=0.42 l=0.15
X11 a_1108_47# a_27_47# a_761_289# VPB sky130_fd_pr__pfet_01v8_hvt ad=0.0588 pd=0.7 as=0.12915 ps=1.185 w=0.42 l=0.15
X12 a_543_47# a_27_47# a_448_47# VNB sky130_fd_pr__nfet_01v8 ad=0.0594 pd=0.69 as=0.066 ps=0.745 w=0.36 l=0.15
X13 a_1462_47# RESET_B VGND VNB sky130_fd_pr__nfet_01v8 ad=0.06405 pd=0.725 as=0.12495 ps=1.015 w=0.42 l=0.15
X14 a_543_47# a_193_47# a_448_47# VPB sky130_fd_pr__pfet_01v8_hvt ad=0.07245 pd=0.765 as=0.0651 ps=0.73 w=0.42 l=0.15
X15 a_448_47# D VGND VNB sky130_fd_pr__nfet_01v8 ad=0.066 pd=0.745 as=0.2205 ps=1.89 w=0.42 l=0.15
X16 VPWR a_1283_21# a_1270_413# VPB sky130_fd_pr__pfet_01v8_hvt ad=0.0819 pd=0.81 as=0.0567 ps=0.69 w=0.42 l=0.15
X17 VPWR a_1108_47# a_1283_21# VPB sky130_fd_pr__pfet_01v8_hvt ad=0.1134 pd=1.38 as=0.0567 ps=0.69 w=0.42 l=0.15
X18 a_1270_413# a_193_47# a_1108_47# VPB sky130_fd_pr__pfet_01v8_hvt ad=0.0567 pd=0.69 as=0.0588 ps=0.7 w=0.42 l=0.15
X19 a_193_47# a_27_47# VPWR VPB sky130_fd_pr__pfet_01v8_hvt ad=0.1664 pd=1.8 as=0.0864 ps=0.91 w=0.64 l=0.15
X20 a_1283_21# RESET_B VPWR VPB sky130_fd_pr__pfet_01v8_hvt ad=0.0567 pd=0.69 as=0.0819 ps=0.81 w=0.42 l=0.15
X21 VPWR a_761_289# a_651_413# VPB sky130_fd_pr__pfet_01v8_hvt ad=0.07035 pd=0.755 as=0.1155 ps=0.97 w=0.42 l=0.15
X22 Q a_1283_21# VGND VNB sky130_fd_pr__nfet_01v8 ad=0.169 pd=1.82 as=0.2087 ps=2.02 w=0.65 l=0.15
X23 a_639_47# a_193_47# a_543_47# VNB sky130_fd_pr__nfet_01v8 ad=0.1401 pd=1.1 as=0.0594 ps=0.69 w=0.36 l=0.15
X24 VGND a_1283_21# a_1217_47# VNB sky130_fd_pr__nfet_01v8 ad=0.12495 pd=1.015 as=0.0669 ps=0.75 w=0.42 l=0.15
X25 a_651_413# RESET_B VPWR VPB sky130_fd_pr__pfet_01v8_hvt ad=0.1092 pd=1.36 as=0.07035 ps=0.755 w=0.42 l=0.15
X26 VGND CLK a_27_47# VNB sky130_fd_pr__nfet_01v8 ad=0.0567 pd=0.69 as=0.1092 ps=1.36 w=0.42 l=0.15
X27 a_761_289# a_543_47# VPWR VPB sky130_fd_pr__pfet_01v8_hvt ad=0.12915 pd=1.185 as=0.2184 ps=2.2 w=0.84 l=0.15
.ends

.subckt sky130_fd_sc_hd__nand2_1 VPB VNB VGND VPWR A Y B
X0 VPWR A Y VPB sky130_fd_pr__pfet_01v8_hvt ad=0.26 pd=2.52 as=0.135 ps=1.27 w=1 l=0.15
X1 Y A a_113_47# VNB sky130_fd_pr__nfet_01v8 ad=0.169 pd=1.82 as=0.08775 ps=0.92 w=0.65 l=0.15
X2 a_113_47# B VGND VNB sky130_fd_pr__nfet_01v8 ad=0.08775 pd=0.92 as=0.169 ps=1.82 w=0.65 l=0.15
X3 Y B VPWR VPB sky130_fd_pr__pfet_01v8_hvt ad=0.135 pd=1.27 as=0.26 ps=2.52 w=1 l=0.15
.ends

.subckt sky130_fd_sc_hd__o21ai_0 VNB VPB VGND VPWR B1 A1 Y A2
X0 a_120_369# A1 VPWR VPB sky130_fd_pr__pfet_01v8_hvt ad=0.0768 pd=0.88 as=0.1696 ps=1.81 w=0.64 l=0.15
X1 VGND A1 a_32_47# VNB sky130_fd_pr__nfet_01v8 ad=0.0588 pd=0.7 as=0.1113 ps=1.37 w=0.42 l=0.15
X2 Y A2 a_120_369# VPB sky130_fd_pr__pfet_01v8_hvt ad=0.0896 pd=0.92 as=0.0768 ps=0.88 w=0.64 l=0.15
X3 a_32_47# A2 VGND VNB sky130_fd_pr__nfet_01v8 ad=0.0588 pd=0.7 as=0.0588 ps=0.7 w=0.42 l=0.15
X4 VPWR B1 Y VPB sky130_fd_pr__pfet_01v8_hvt ad=0.1824 pd=1.85 as=0.0896 ps=0.92 w=0.64 l=0.15
X5 Y B1 a_32_47# VNB sky130_fd_pr__nfet_01v8 ad=0.1113 pd=1.37 as=0.0588 ps=0.7 w=0.42 l=0.15
.ends

.subckt sky130_fd_sc_hd__dfxtp_1 Q CLK D VPB VNB VPWR VGND
X0 Q a_1059_315# VGND VNB sky130_fd_pr__nfet_01v8 ad=0.169 pd=1.82 as=0.08775 ps=0.92 w=0.65 l=0.15
X1 a_891_413# a_193_47# a_634_159# VNB sky130_fd_pr__nfet_01v8 ad=0.0684 pd=0.74 as=0.0989 ps=0.995 w=0.36 l=0.15
X2 a_561_413# a_27_47# a_466_413# VPB sky130_fd_pr__pfet_01v8_hvt ad=0.07665 pd=0.785 as=0.06825 ps=0.745 w=0.42 l=0.15
X3 VPWR CLK a_27_47# VPB sky130_fd_pr__pfet_01v8_hvt ad=0.0864 pd=0.91 as=0.1664 ps=1.8 w=0.64 l=0.15
X4 Q a_1059_315# VPWR VPB sky130_fd_pr__pfet_01v8_hvt ad=0.26 pd=2.52 as=0.135 ps=1.27 w=1 l=0.15
X5 a_381_47# D VPWR VPB sky130_fd_pr__pfet_01v8_hvt ad=0.05775 pd=0.695 as=0.1092 ps=1.36 w=0.42 l=0.15
X6 VGND a_634_159# a_592_47# VNB sky130_fd_pr__nfet_01v8 ad=0.12095 pd=1.085 as=0.0696 ps=0.765 w=0.42 l=0.15
X7 VPWR a_891_413# a_1059_315# VPB sky130_fd_pr__pfet_01v8_hvt ad=0.135 pd=1.27 as=0.27 ps=2.54 w=1 l=0.15
X8 a_466_413# a_193_47# a_381_47# VPB sky130_fd_pr__pfet_01v8_hvt ad=0.06825 pd=0.745 as=0.05775 ps=0.695 w=0.42 l=0.15
X9 VPWR a_634_159# a_561_413# VPB sky130_fd_pr__pfet_01v8_hvt ad=0.17887 pd=1.26 as=0.07665 ps=0.785 w=0.42 l=0.15
X10 a_634_159# a_466_413# VGND VNB sky130_fd_pr__nfet_01v8 ad=0.0989 pd=0.995 as=0.12095 ps=1.085 w=0.64 l=0.15
X11 a_634_159# a_466_413# VPWR VPB sky130_fd_pr__pfet_01v8_hvt ad=0.1095 pd=1.075 as=0.17887 ps=1.26 w=0.75 l=0.15
X12 a_975_413# a_193_47# a_891_413# VPB sky130_fd_pr__pfet_01v8_hvt ad=0.0882 pd=0.84 as=0.0567 ps=0.69 w=0.42 l=0.15
X13 VGND a_1059_315# a_1017_47# VNB sky130_fd_pr__nfet_01v8 ad=0.1092 pd=1.36 as=0.066 ps=0.745 w=0.42 l=0.15
X14 a_193_47# a_27_47# VGND VNB sky130_fd_pr__nfet_01v8 ad=0.1092 pd=1.36 as=0.0567 ps=0.69 w=0.42 l=0.15
X15 a_891_413# a_27_47# a_634_159# VPB sky130_fd_pr__pfet_01v8_hvt ad=0.0567 pd=0.69 as=0.1095 ps=1.075 w=0.42 l=0.15
X16 a_592_47# a_193_47# a_466_413# VNB sky130_fd_pr__nfet_01v8 ad=0.0696 pd=0.765 as=0.0621 ps=0.705 w=0.36 l=0.15
X17 a_1017_47# a_27_47# a_891_413# VNB sky130_fd_pr__nfet_01v8 ad=0.066 pd=0.745 as=0.0684 ps=0.74 w=0.36 l=0.15
X18 VPWR a_1059_315# a_975_413# VPB sky130_fd_pr__pfet_01v8_hvt ad=0.1113 pd=1.37 as=0.0882 ps=0.84 w=0.42 l=0.15
X19 a_466_413# a_27_47# a_381_47# VNB sky130_fd_pr__nfet_01v8 ad=0.0621 pd=0.705 as=0.0813 ps=0.83 w=0.36 l=0.15
X20 a_193_47# a_27_47# VPWR VPB sky130_fd_pr__pfet_01v8_hvt ad=0.1664 pd=1.8 as=0.0864 ps=0.91 w=0.64 l=0.15
X21 VGND a_891_413# a_1059_315# VNB sky130_fd_pr__nfet_01v8 ad=0.08775 pd=0.92 as=0.169 ps=1.82 w=0.65 l=0.15
X22 a_381_47# D VGND VNB sky130_fd_pr__nfet_01v8 ad=0.0813 pd=0.83 as=0.1092 ps=1.36 w=0.42 l=0.15
X23 VGND CLK a_27_47# VNB sky130_fd_pr__nfet_01v8 ad=0.0567 pd=0.69 as=0.1092 ps=1.36 w=0.42 l=0.15
.ends

.subckt sky130_fd_sc_hd__nor4_1 VPB VNB VGND VPWR Y D C B A
X0 Y B VGND VNB sky130_fd_pr__nfet_01v8 ad=0.08775 pd=0.92 as=0.08937 ps=0.925 w=0.65 l=0.15
X1 a_191_297# C a_109_297# VPB sky130_fd_pr__pfet_01v8_hvt ad=0.19 pd=1.38 as=0.13 ps=1.26 w=1 l=0.15
X2 VPWR A a_297_297# VPB sky130_fd_pr__pfet_01v8_hvt ad=0.26 pd=2.52 as=0.135 ps=1.27 w=1 l=0.15
X3 VGND C Y VNB sky130_fd_pr__nfet_01v8 ad=0.08937 pd=0.925 as=0.11863 ps=1.015 w=0.65 l=0.15
X4 VGND A Y VNB sky130_fd_pr__nfet_01v8 ad=0.169 pd=1.82 as=0.08775 ps=0.92 w=0.65 l=0.15
X5 a_297_297# B a_191_297# VPB sky130_fd_pr__pfet_01v8_hvt ad=0.135 pd=1.27 as=0.19 ps=1.38 w=1 l=0.15
X6 a_109_297# D Y VPB sky130_fd_pr__pfet_01v8_hvt ad=0.13 pd=1.26 as=0.26 ps=2.52 w=1 l=0.15
X7 Y D VGND VNB sky130_fd_pr__nfet_01v8 ad=0.11863 pd=1.015 as=0.169 ps=1.82 w=0.65 l=0.15
.ends

.subckt sky130_fd_sc_hd__o21a_1 VPB VNB VGND VPWR A1 A2 B1 X
X0 VPWR A1 a_382_297# VPB sky130_fd_pr__pfet_01v8_hvt ad=0.26 pd=2.52 as=0.1525 ps=1.305 w=1 l=0.15
X1 a_297_47# B1 a_79_21# VNB sky130_fd_pr__nfet_01v8 ad=0.10075 pd=0.96 as=0.169 ps=1.82 w=0.65 l=0.15
X2 a_297_47# A1 VGND VNB sky130_fd_pr__nfet_01v8 ad=0.169 pd=1.82 as=0.08775 ps=0.92 w=0.65 l=0.15
X3 VGND A2 a_297_47# VNB sky130_fd_pr__nfet_01v8 ad=0.08775 pd=0.92 as=0.10075 ps=0.96 w=0.65 l=0.15
X4 VPWR a_79_21# X VPB sky130_fd_pr__pfet_01v8_hvt ad=0.3275 pd=1.655 as=0.28 ps=2.56 w=1 l=0.15
X5 a_79_21# B1 VPWR VPB sky130_fd_pr__pfet_01v8_hvt ad=0.195 pd=1.39 as=0.3275 ps=1.655 w=1 l=0.15
X6 a_382_297# A2 a_79_21# VPB sky130_fd_pr__pfet_01v8_hvt ad=0.1525 pd=1.305 as=0.195 ps=1.39 w=1 l=0.15
X7 VGND a_79_21# X VNB sky130_fd_pr__nfet_01v8 ad=0.169 pd=1.82 as=0.169 ps=1.82 w=0.65 l=0.15
.ends

.subckt sky130_fd_sc_hd__a222oi_1 VNB VPB VPWR VGND C2 C1 B1 A2 A1 Y B2
X0 Y B1 a_393_47# VNB sky130_fd_pr__nfet_01v8 ad=0.1056 pd=0.97 as=0.0672 ps=0.85 w=0.64 l=0.15
X1 VGND A2 a_561_47# VNB sky130_fd_pr__nfet_01v8 ad=0.1664 pd=1.8 as=0.1056 ps=0.97 w=0.64 l=0.15
X2 VGND C2 a_109_47# VNB sky130_fd_pr__nfet_01v8 ad=0.2912 pd=1.55 as=0.0672 ps=0.85 w=0.64 l=0.15
X3 Y C2 a_109_297# VPB sky130_fd_pr__pfet_01v8_hvt ad=0.26 pd=2.52 as=0.135 ps=1.27 w=1 l=0.15
X4 VPWR A1 a_311_297# VPB sky130_fd_pr__pfet_01v8_hvt ad=0.165 pd=1.33 as=0.135 ps=1.27 w=1 l=0.15
X5 a_311_297# A2 VPWR VPB sky130_fd_pr__pfet_01v8_hvt ad=0.26 pd=2.52 as=0.165 ps=1.33 w=1 l=0.15
X6 a_311_297# B1 a_109_297# VPB sky130_fd_pr__pfet_01v8_hvt ad=0.135 pd=1.27 as=0.135 ps=1.27 w=1 l=0.15
X7 a_109_297# B2 a_311_297# VPB sky130_fd_pr__pfet_01v8_hvt ad=0.135 pd=1.27 as=0.26 ps=2.52 w=1 l=0.15
X8 a_109_297# C1 Y VPB sky130_fd_pr__pfet_01v8_hvt ad=0.135 pd=1.27 as=0.26 ps=2.52 w=1 l=0.15
X9 a_393_47# B2 VGND VNB sky130_fd_pr__nfet_01v8 ad=0.0672 pd=0.85 as=0.2912 ps=1.55 w=0.64 l=0.15
X10 a_109_47# C1 Y VNB sky130_fd_pr__nfet_01v8 ad=0.0672 pd=0.85 as=0.1664 ps=1.8 w=0.64 l=0.15
X11 a_561_47# A1 Y VNB sky130_fd_pr__nfet_01v8 ad=0.1056 pd=0.97 as=0.1056 ps=0.97 w=0.64 l=0.15
.ends

.subckt sky130_fd_sc_hd__clkbuf_16 VNB VPB VGND VPWR A X
X0 VPWR A a_110_47# VPB sky130_fd_pr__pfet_01v8_hvt ad=0.14 pd=1.28 as=0.14 ps=1.28 w=1 l=0.15
X1 VPWR a_110_47# X VPB sky130_fd_pr__pfet_01v8_hvt ad=0.14 pd=1.28 as=0.14 ps=1.28 w=1 l=0.15
X2 X a_110_47# VPWR VPB sky130_fd_pr__pfet_01v8_hvt ad=0.14 pd=1.28 as=0.14 ps=1.28 w=1 l=0.15
X3 X a_110_47# VPWR VPB sky130_fd_pr__pfet_01v8_hvt ad=0.14 pd=1.28 as=0.14 ps=1.28 w=1 l=0.15
X4 VPWR a_110_47# X VPB sky130_fd_pr__pfet_01v8_hvt ad=0.14 pd=1.28 as=0.14 ps=1.28 w=1 l=0.15
X5 VPWR a_110_47# X VPB sky130_fd_pr__pfet_01v8_hvt ad=0.265 pd=2.53 as=0.14 ps=1.28 w=1 l=0.15
X6 a_110_47# A VPWR VPB sky130_fd_pr__pfet_01v8_hvt ad=0.14 pd=1.28 as=0.265 ps=2.53 w=1 l=0.15
X7 a_110_47# A VGND VNB sky130_fd_pr__nfet_01v8 ad=0.0588 pd=0.7 as=0.0588 ps=0.7 w=0.42 l=0.15
X8 VGND a_110_47# X VNB sky130_fd_pr__nfet_01v8 ad=0.0588 pd=0.7 as=0.0588 ps=0.7 w=0.42 l=0.15
X9 X a_110_47# VGND VNB sky130_fd_pr__nfet_01v8 ad=0.0588 pd=0.7 as=0.0588 ps=0.7 w=0.42 l=0.15
X10 VGND a_110_47# X VNB sky130_fd_pr__nfet_01v8 ad=0.0588 pd=0.7 as=0.0588 ps=0.7 w=0.42 l=0.15
X11 a_110_47# A VPWR VPB sky130_fd_pr__pfet_01v8_hvt ad=0.14 pd=1.28 as=0.14 ps=1.28 w=1 l=0.15
X12 VGND A a_110_47# VNB sky130_fd_pr__nfet_01v8 ad=0.0588 pd=0.7 as=0.0588 ps=0.7 w=0.42 l=0.15
X13 VGND a_110_47# X VNB sky130_fd_pr__nfet_01v8 ad=0.05775 pd=0.695 as=0.0588 ps=0.7 w=0.42 l=0.15
X14 VPWR a_110_47# X VPB sky130_fd_pr__pfet_01v8_hvt ad=0.14 pd=1.28 as=0.14 ps=1.28 w=1 l=0.15
X15 X a_110_47# VPWR VPB sky130_fd_pr__pfet_01v8_hvt ad=0.14 pd=1.28 as=0.14 ps=1.28 w=1 l=0.15
X16 VGND A a_110_47# VNB sky130_fd_pr__nfet_01v8 ad=0.0588 pd=0.7 as=0.0588 ps=0.7 w=0.42 l=0.15
X17 VGND a_110_47# X VNB sky130_fd_pr__nfet_01v8 ad=0.1113 pd=1.37 as=0.0588 ps=0.7 w=0.42 l=0.15
X18 VPWR a_110_47# X VPB sky130_fd_pr__pfet_01v8_hvt ad=0.1375 pd=1.275 as=0.14 ps=1.28 w=1 l=0.15
X19 VGND a_110_47# X VNB sky130_fd_pr__nfet_01v8 ad=0.0588 pd=0.7 as=0.0588 ps=0.7 w=0.42 l=0.15
X20 X a_110_47# VPWR VPB sky130_fd_pr__pfet_01v8_hvt ad=0.14 pd=1.28 as=0.1375 ps=1.275 w=1 l=0.15
X21 a_110_47# A VGND VNB sky130_fd_pr__nfet_01v8 ad=0.0588 pd=0.7 as=0.1113 ps=1.37 w=0.42 l=0.15
X22 VPWR A a_110_47# VPB sky130_fd_pr__pfet_01v8_hvt ad=0.14 pd=1.28 as=0.14 ps=1.28 w=1 l=0.15
X23 VPWR a_110_47# X VPB sky130_fd_pr__pfet_01v8_hvt ad=0.14 pd=1.28 as=0.14 ps=1.28 w=1 l=0.15
X24 VPWR a_110_47# X VPB sky130_fd_pr__pfet_01v8_hvt ad=0.14 pd=1.28 as=0.14 ps=1.28 w=1 l=0.15
X25 VGND a_110_47# X VNB sky130_fd_pr__nfet_01v8 ad=0.0588 pd=0.7 as=0.0588 ps=0.7 w=0.42 l=0.15
X26 X a_110_47# VPWR VPB sky130_fd_pr__pfet_01v8_hvt ad=0.14 pd=1.28 as=0.14 ps=1.28 w=1 l=0.15
X27 VGND a_110_47# X VNB sky130_fd_pr__nfet_01v8 ad=0.0588 pd=0.7 as=0.0588 ps=0.7 w=0.42 l=0.15
X28 VGND a_110_47# X VNB sky130_fd_pr__nfet_01v8 ad=0.0588 pd=0.7 as=0.0588 ps=0.7 w=0.42 l=0.15
X29 X a_110_47# VGND VNB sky130_fd_pr__nfet_01v8 ad=0.0588 pd=0.7 as=0.0588 ps=0.7 w=0.42 l=0.15
X30 X a_110_47# VPWR VPB sky130_fd_pr__pfet_01v8_hvt ad=0.14 pd=1.28 as=0.14 ps=1.28 w=1 l=0.15
X31 X a_110_47# VPWR VPB sky130_fd_pr__pfet_01v8_hvt ad=0.14 pd=1.28 as=0.14 ps=1.28 w=1 l=0.15
X32 X a_110_47# VGND VNB sky130_fd_pr__nfet_01v8 ad=0.0588 pd=0.7 as=0.0588 ps=0.7 w=0.42 l=0.15
X33 VPWR a_110_47# X VPB sky130_fd_pr__pfet_01v8_hvt ad=0.14 pd=1.28 as=0.14 ps=1.28 w=1 l=0.15
X34 X a_110_47# VPWR VPB sky130_fd_pr__pfet_01v8_hvt ad=0.14 pd=1.28 as=0.14 ps=1.28 w=1 l=0.15
X35 X a_110_47# VGND VNB sky130_fd_pr__nfet_01v8 ad=0.0588 pd=0.7 as=0.0588 ps=0.7 w=0.42 l=0.15
X36 X a_110_47# VGND VNB sky130_fd_pr__nfet_01v8 ad=0.0588 pd=0.7 as=0.0588 ps=0.7 w=0.42 l=0.15
X37 X a_110_47# VGND VNB sky130_fd_pr__nfet_01v8 ad=0.0588 pd=0.7 as=0.0588 ps=0.7 w=0.42 l=0.15
X38 X a_110_47# VGND VNB sky130_fd_pr__nfet_01v8 ad=0.0588 pd=0.7 as=0.0588 ps=0.7 w=0.42 l=0.15
X39 X a_110_47# VGND VNB sky130_fd_pr__nfet_01v8 ad=0.0588 pd=0.7 as=0.05775 ps=0.695 w=0.42 l=0.15
.ends

.subckt sky130_fd_sc_hd__nand4b_1 VPB VNB VGND VPWR Y C B D A_N
X0 Y B VPWR VPB sky130_fd_pr__pfet_01v8_hvt ad=0.195 pd=1.39 as=0.1925 ps=1.385 w=1 l=0.15
X1 a_232_47# D VGND VNB sky130_fd_pr__nfet_01v8 ad=0.08775 pd=0.92 as=0.11812 ps=1.04 w=0.65 l=0.15
X2 VPWR C Y VPB sky130_fd_pr__pfet_01v8_hvt ad=0.1925 pd=1.385 as=0.135 ps=1.27 w=1 l=0.15
X3 VPWR A_N a_41_93# VPB sky130_fd_pr__pfet_01v8_hvt ad=0.14575 pd=1.335 as=0.1092 ps=1.36 w=0.42 l=0.15
X4 VPWR a_41_93# Y VPB sky130_fd_pr__pfet_01v8_hvt ad=0.28 pd=2.56 as=0.195 ps=1.39 w=1 l=0.15
X5 a_316_47# C a_232_47# VNB sky130_fd_pr__nfet_01v8 ad=0.12513 pd=1.035 as=0.08775 ps=0.92 w=0.65 l=0.15
X6 Y a_41_93# a_423_47# VNB sky130_fd_pr__nfet_01v8 ad=0.2275 pd=2 as=0.12675 ps=1.04 w=0.65 l=0.15
X7 a_423_47# B a_316_47# VNB sky130_fd_pr__nfet_01v8 ad=0.12675 pd=1.04 as=0.12513 ps=1.035 w=0.65 l=0.15
X8 Y D VPWR VPB sky130_fd_pr__pfet_01v8_hvt ad=0.135 pd=1.27 as=0.14575 ps=1.335 w=1 l=0.15
X9 VGND A_N a_41_93# VNB sky130_fd_pr__nfet_01v8 ad=0.11812 pd=1.04 as=0.1113 ps=1.37 w=0.42 l=0.15
.ends

.subckt sky130_fd_sc_hd__nand3_1 VPB VNB VGND VPWR A B Y C
X0 VPWR B Y VPB sky130_fd_pr__pfet_01v8_hvt ad=0.165 pd=1.33 as=0.135 ps=1.27 w=1 l=0.15
X1 Y A VPWR VPB sky130_fd_pr__pfet_01v8_hvt ad=0.26 pd=2.52 as=0.165 ps=1.33 w=1 l=0.15
X2 a_193_47# B a_109_47# VNB sky130_fd_pr__nfet_01v8 ad=0.10725 pd=0.98 as=0.08775 ps=0.92 w=0.65 l=0.15
X3 Y A a_193_47# VNB sky130_fd_pr__nfet_01v8 ad=0.169 pd=1.82 as=0.10725 ps=0.98 w=0.65 l=0.15
X4 Y C VPWR VPB sky130_fd_pr__pfet_01v8_hvt ad=0.135 pd=1.27 as=0.26 ps=2.52 w=1 l=0.15
X5 a_109_47# C VGND VNB sky130_fd_pr__nfet_01v8 ad=0.08775 pd=0.92 as=0.169 ps=1.82 w=0.65 l=0.15
.ends

.subckt sky130_fd_sc_hd__a21oi_1 VPWR VGND VPB VNB A2 A1 B1 Y
X0 a_199_47# A1 Y VNB sky130_fd_pr__nfet_01v8 ad=0.09588 pd=0.945 as=0.091 ps=0.93 w=0.65 l=0.15
X1 a_113_297# A2 VPWR VPB sky130_fd_pr__pfet_01v8_hvt ad=0.265 pd=2.53 as=0.1475 ps=1.295 w=1 l=0.15
X2 Y B1 VGND VNB sky130_fd_pr__nfet_01v8 ad=0.091 pd=0.93 as=0.17225 ps=1.83 w=0.65 l=0.15
X3 VPWR A1 a_113_297# VPB sky130_fd_pr__pfet_01v8_hvt ad=0.1475 pd=1.295 as=0.14 ps=1.28 w=1 l=0.15
X4 a_113_297# B1 Y VPB sky130_fd_pr__pfet_01v8_hvt ad=0.14 pd=1.28 as=0.265 ps=2.53 w=1 l=0.15
X5 VGND A2 a_199_47# VNB sky130_fd_pr__nfet_01v8 ad=0.17225 pd=1.83 as=0.09588 ps=0.945 w=0.65 l=0.15
.ends

.subckt sky130_fd_sc_hd__or4b_1 VPWR VGND VPB VNB B C A X D_N
X0 X a_215_297# VPWR VPB sky130_fd_pr__pfet_01v8_hvt ad=0.275 pd=2.55 as=0.14825 ps=1.34 w=1 l=0.15
X1 a_109_53# D_N VGND VNB sky130_fd_pr__nfet_01v8 ad=0.1092 pd=1.36 as=0.1092 ps=1.36 w=0.42 l=0.15
X2 a_215_297# a_109_53# VGND VNB sky130_fd_pr__nfet_01v8 ad=0.06405 pd=0.725 as=0.1092 ps=1.36 w=0.42 l=0.15
X3 X a_215_297# VGND VNB sky130_fd_pr__nfet_01v8 ad=0.17875 pd=1.85 as=0.10187 ps=0.99 w=0.65 l=0.15
X4 a_392_297# C a_297_297# VPB sky130_fd_pr__pfet_01v8_hvt ad=0.04515 pd=0.635 as=0.06825 ps=0.745 w=0.42 l=0.15
X5 a_465_297# B a_392_297# VPB sky130_fd_pr__pfet_01v8_hvt ad=0.06405 pd=0.725 as=0.04515 ps=0.635 w=0.42 l=0.15
X6 a_215_297# B VGND VNB sky130_fd_pr__nfet_01v8 ad=0.0567 pd=0.69 as=0.0567 ps=0.69 w=0.42 l=0.15
X7 VPWR A a_465_297# VPB sky130_fd_pr__pfet_01v8_hvt ad=0.14825 pd=1.34 as=0.06405 ps=0.725 w=0.42 l=0.15
X8 a_297_297# a_109_53# a_215_297# VPB sky130_fd_pr__pfet_01v8_hvt ad=0.06825 pd=0.745 as=0.1092 ps=1.36 w=0.42 l=0.15
X9 a_109_53# D_N VPWR VPB sky130_fd_pr__pfet_01v8_hvt ad=0.1092 pd=1.36 as=0.1092 ps=1.36 w=0.42 l=0.15
X10 VGND C a_215_297# VNB sky130_fd_pr__nfet_01v8 ad=0.0567 pd=0.69 as=0.06405 ps=0.725 w=0.42 l=0.15
X11 VGND A a_215_297# VNB sky130_fd_pr__nfet_01v8 ad=0.10187 pd=0.99 as=0.0567 ps=0.69 w=0.42 l=0.15
.ends

.subckt sky130_fd_sc_hd__nor3_1 VPB VNB VGND VPWR C B A Y
X0 VPWR A a_193_297# VPB sky130_fd_pr__pfet_01v8_hvt ad=0.26 pd=2.52 as=0.135 ps=1.27 w=1 l=0.15
X1 a_193_297# B a_109_297# VPB sky130_fd_pr__pfet_01v8_hvt ad=0.135 pd=1.27 as=0.135 ps=1.27 w=1 l=0.15
X2 Y B VGND VNB sky130_fd_pr__nfet_01v8 ad=0.08775 pd=0.92 as=0.08775 ps=0.92 w=0.65 l=0.15
X3 VGND A Y VNB sky130_fd_pr__nfet_01v8 ad=0.169 pd=1.82 as=0.08775 ps=0.92 w=0.65 l=0.15
X4 a_109_297# C Y VPB sky130_fd_pr__pfet_01v8_hvt ad=0.135 pd=1.27 as=0.26 ps=2.52 w=1 l=0.15
X5 VGND C Y VNB sky130_fd_pr__nfet_01v8 ad=0.08775 pd=0.92 as=0.169 ps=1.82 w=0.65 l=0.15
.ends

.subckt sky130_fd_sc_hd__a22oi_1 VPWR VGND VPB VNB B2 B1 Y A1 A2
X0 Y B1 a_109_47# VNB sky130_fd_pr__nfet_01v8 ad=0.169 pd=1.82 as=0.07475 ps=0.88 w=0.65 l=0.15
X1 Y B1 a_109_297# VPB sky130_fd_pr__pfet_01v8_hvt ad=0.26 pd=2.52 as=0.135 ps=1.27 w=1 l=0.15
X2 VPWR A2 a_109_297# VPB sky130_fd_pr__pfet_01v8_hvt ad=0.3 pd=2.6 as=0.135 ps=1.27 w=1 l=0.15
X3 a_109_297# A1 VPWR VPB sky130_fd_pr__pfet_01v8_hvt ad=0.135 pd=1.27 as=0.26 ps=2.52 w=1 l=0.15
X4 a_381_47# A1 Y VNB sky130_fd_pr__nfet_01v8 ad=0.06825 pd=0.86 as=0.169 ps=1.82 w=0.65 l=0.15
X5 a_109_297# B2 Y VPB sky130_fd_pr__pfet_01v8_hvt ad=0.135 pd=1.27 as=0.26 ps=2.52 w=1 l=0.15
X6 a_109_47# B2 VGND VNB sky130_fd_pr__nfet_01v8 ad=0.07475 pd=0.88 as=0.169 ps=1.82 w=0.65 l=0.15
X7 VGND A2 a_381_47# VNB sky130_fd_pr__nfet_01v8 ad=0.234 pd=2.02 as=0.06825 ps=0.86 w=0.65 l=0.15
.ends

.subckt sky130_fd_sc_hd__o41ai_1 VNB VPB VGND VPWR A1 A2 A3 A4 Y B1
X0 a_348_297# A3 a_193_297# VPB sky130_fd_pr__pfet_01v8_hvt ad=0.135 pd=1.27 as=0.3125 ps=1.625 w=1 l=0.15
X1 a_109_47# A1 VGND VNB sky130_fd_pr__nfet_01v8 ad=0.182 pd=1.86 as=0.11375 ps=1 w=0.65 l=0.15
X2 a_193_297# A4 Y VPB sky130_fd_pr__pfet_01v8_hvt ad=0.3125 pd=1.625 as=0.135 ps=1.27 w=1 l=0.15
X3 VPWR A1 a_432_297# VPB sky130_fd_pr__pfet_01v8_hvt ad=0.28 pd=2.56 as=0.175 ps=1.35 w=1 l=0.15
X4 VGND A4 a_109_47# VNB sky130_fd_pr__nfet_01v8 ad=0.08775 pd=0.92 as=0.20312 ps=1.275 w=0.65 l=0.15
X5 VGND A2 a_109_47# VNB sky130_fd_pr__nfet_01v8 ad=0.11375 pd=1 as=0.08775 ps=0.92 w=0.65 l=0.15
X6 a_109_47# A3 VGND VNB sky130_fd_pr__nfet_01v8 ad=0.08775 pd=0.92 as=0.08775 ps=0.92 w=0.65 l=0.15
X7 a_432_297# A2 a_348_297# VPB sky130_fd_pr__pfet_01v8_hvt ad=0.175 pd=1.35 as=0.135 ps=1.27 w=1 l=0.15
X8 Y B1 VPWR VPB sky130_fd_pr__pfet_01v8_hvt ad=0.135 pd=1.27 as=0.26 ps=2.52 w=1 l=0.15
X9 a_109_47# B1 Y VNB sky130_fd_pr__nfet_01v8 ad=0.20312 pd=1.275 as=0.169 ps=1.82 w=0.65 l=0.15
.ends

.subckt sky130_fd_sc_hd__decap_3 VPWR VGND VPB VNB
X0 VPWR VGND VPWR VPB sky130_fd_pr__pfet_01v8_hvt ad=0.2262 pd=2.26 as=0.4524 ps=4.52 w=0.87 l=0.59
X1 VGND VPWR VGND VNB sky130_fd_pr__nfet_01v8 ad=0.143 pd=1.62 as=0.286 ps=3.24 w=0.55 l=0.59
.ends

.subckt sky130_fd_sc_hd__lpflow_inputiso1p_1 VPB VNB VGND VPWR X SLEEP A
X0 VGND SLEEP a_68_297# VNB sky130_fd_pr__nfet_01v8 ad=0.10025 pd=0.985 as=0.0567 ps=0.69 w=0.42 l=0.15
X1 a_68_297# A VGND VNB sky130_fd_pr__nfet_01v8 ad=0.0567 pd=0.69 as=0.1092 ps=1.36 w=0.42 l=0.15
X2 X a_68_297# VGND VNB sky130_fd_pr__nfet_01v8 ad=0.169 pd=1.82 as=0.10025 ps=0.985 w=0.65 l=0.15
X3 VPWR SLEEP a_150_297# VPB sky130_fd_pr__pfet_01v8_hvt ad=0.14575 pd=1.335 as=0.0441 ps=0.63 w=0.42 l=0.15
X4 X a_68_297# VPWR VPB sky130_fd_pr__pfet_01v8_hvt ad=0.34 pd=2.68 as=0.14575 ps=1.335 w=1 l=0.15
X5 a_150_297# A a_68_297# VPB sky130_fd_pr__pfet_01v8_hvt ad=0.0441 pd=0.63 as=0.1092 ps=1.36 w=0.42 l=0.15
.ends

.subckt sky130_fd_sc_hd__nand4_1 VPB VNB VPWR VGND A C D Y B
X0 Y B VPWR VPB sky130_fd_pr__pfet_01v8_hvt ad=0.165 pd=1.33 as=0.135 ps=1.27 w=1 l=0.15
X1 VPWR A Y VPB sky130_fd_pr__pfet_01v8_hvt ad=0.3 pd=2.6 as=0.165 ps=1.33 w=1 l=0.15
X2 VPWR C Y VPB sky130_fd_pr__pfet_01v8_hvt ad=0.135 pd=1.27 as=0.135 ps=1.27 w=1 l=0.15
X3 a_193_47# C a_109_47# VNB sky130_fd_pr__nfet_01v8 ad=0.08775 pd=0.92 as=0.08775 ps=0.92 w=0.65 l=0.15
X4 Y A a_277_47# VNB sky130_fd_pr__nfet_01v8 ad=0.195 pd=1.9 as=0.10725 ps=0.98 w=0.65 l=0.15
X5 a_277_47# B a_193_47# VNB sky130_fd_pr__nfet_01v8 ad=0.10725 pd=0.98 as=0.08775 ps=0.92 w=0.65 l=0.15
X6 Y D VPWR VPB sky130_fd_pr__pfet_01v8_hvt ad=0.135 pd=1.27 as=0.26 ps=2.52 w=1 l=0.15
X7 a_109_47# D VGND VNB sky130_fd_pr__nfet_01v8 ad=0.08775 pd=0.92 as=0.169 ps=1.82 w=0.65 l=0.15
.ends

.subckt sky130_fd_sc_hd__a21o_1 VPWR VGND VPB VNB A2 A1 B1 X
X0 a_81_21# B1 VGND VNB sky130_fd_pr__nfet_01v8 ad=0.08937 pd=0.925 as=0.25675 ps=1.44 w=0.65 l=0.15
X1 a_299_297# B1 a_81_21# VPB sky130_fd_pr__pfet_01v8_hvt ad=0.1375 pd=1.275 as=0.26 ps=2.52 w=1 l=0.15
X2 VPWR a_81_21# X VPB sky130_fd_pr__pfet_01v8_hvt ad=0.26 pd=2.52 as=0.26 ps=2.52 w=1 l=0.15
X3 VPWR A1 a_299_297# VPB sky130_fd_pr__pfet_01v8_hvt ad=0.14 pd=1.28 as=0.1375 ps=1.275 w=1 l=0.15
X4 VGND a_81_21# X VNB sky130_fd_pr__nfet_01v8 ad=0.25675 pd=1.44 as=0.169 ps=1.82 w=0.65 l=0.15
X5 VGND A2 a_384_47# VNB sky130_fd_pr__nfet_01v8 ad=0.17225 pd=1.83 as=0.091 ps=0.93 w=0.65 l=0.15
X6 a_299_297# A2 VPWR VPB sky130_fd_pr__pfet_01v8_hvt ad=0.265 pd=2.53 as=0.14 ps=1.28 w=1 l=0.15
X7 a_384_47# A1 a_81_21# VNB sky130_fd_pr__nfet_01v8 ad=0.091 pd=0.93 as=0.08937 ps=0.925 w=0.65 l=0.15
.ends

.subckt sky130_fd_sc_hd__nor2_1 VPB VNB VGND VPWR A B Y
X0 VPWR A a_109_297# VPB sky130_fd_pr__pfet_01v8_hvt ad=0.26 pd=2.52 as=0.105 ps=1.21 w=1 l=0.15
X1 VGND A Y VNB sky130_fd_pr__nfet_01v8 ad=0.169 pd=1.82 as=0.08775 ps=0.92 w=0.65 l=0.15
X2 a_109_297# B Y VPB sky130_fd_pr__pfet_01v8_hvt ad=0.105 pd=1.21 as=0.26 ps=2.52 w=1 l=0.15
X3 Y B VGND VNB sky130_fd_pr__nfet_01v8 ad=0.08775 pd=0.92 as=0.169 ps=1.82 w=0.65 l=0.15
.ends

.subckt sky130_fd_sc_hd__nand2b_1 VPB VNB VGND VPWR A_N B Y
X0 VGND A_N a_27_93# VNB sky130_fd_pr__nfet_01v8 ad=0.10025 pd=0.985 as=0.1092 ps=1.36 w=0.42 l=0.15
X1 Y a_27_93# a_206_47# VNB sky130_fd_pr__nfet_01v8 ad=0.169 pd=1.82 as=0.08775 ps=0.92 w=0.65 l=0.15
X2 a_206_47# B VGND VNB sky130_fd_pr__nfet_01v8 ad=0.08775 pd=0.92 as=0.10025 ps=0.985 w=0.65 l=0.15
X3 VPWR a_27_93# Y VPB sky130_fd_pr__pfet_01v8_hvt ad=0.265 pd=2.53 as=0.135 ps=1.27 w=1 l=0.15
X4 Y B VPWR VPB sky130_fd_pr__pfet_01v8_hvt ad=0.135 pd=1.27 as=0.14575 ps=1.335 w=1 l=0.15
X5 VPWR A_N a_27_93# VPB sky130_fd_pr__pfet_01v8_hvt ad=0.14575 pd=1.335 as=0.1092 ps=1.36 w=0.42 l=0.15
.ends

.subckt sky130_fd_sc_hd__o31ai_1 VPB VNB A1 A2 A3 Y B1 VPWR VGND
X0 Y B1 a_109_47# VNB sky130_fd_pr__nfet_01v8 ad=0.221 pd=1.98 as=0.19825 ps=1.26 w=0.65 l=0.15
X1 Y A3 a_193_297# VPB sky130_fd_pr__pfet_01v8_hvt ad=0.3925 pd=1.785 as=0.135 ps=1.27 w=1 l=0.15
X2 a_193_297# A2 a_109_297# VPB sky130_fd_pr__pfet_01v8_hvt ad=0.135 pd=1.27 as=0.135 ps=1.27 w=1 l=0.15
X3 VGND A2 a_109_47# VNB sky130_fd_pr__nfet_01v8 ad=0.08775 pd=0.92 as=0.08775 ps=0.92 w=0.65 l=0.15
X4 VPWR B1 Y VPB sky130_fd_pr__pfet_01v8_hvt ad=0.3 pd=2.6 as=0.3925 ps=1.785 w=1 l=0.15
X5 a_109_47# A3 VGND VNB sky130_fd_pr__nfet_01v8 ad=0.19825 pd=1.26 as=0.08775 ps=0.92 w=0.65 l=0.15
X6 a_109_297# A1 VPWR VPB sky130_fd_pr__pfet_01v8_hvt ad=0.135 pd=1.27 as=0.26 ps=2.52 w=1 l=0.15
X7 a_109_47# A1 VGND VNB sky130_fd_pr__nfet_01v8 ad=0.08775 pd=0.92 as=0.169 ps=1.82 w=0.65 l=0.15
.ends

.subckt sky130_fd_sc_hd__or3_1 VPWR VGND VPB VNB B C A X
X0 X a_29_53# VPWR VPB sky130_fd_pr__pfet_01v8_hvt ad=0.28 pd=2.56 as=0.14825 ps=1.34 w=1 l=0.15
X1 a_111_297# C a_29_53# VPB sky130_fd_pr__pfet_01v8_hvt ad=0.0441 pd=0.63 as=0.1092 ps=1.36 w=0.42 l=0.15
X2 X a_29_53# VGND VNB sky130_fd_pr__nfet_01v8 ad=0.182 pd=1.86 as=0.10187 ps=0.99 w=0.65 l=0.15
X3 a_183_297# B a_111_297# VPB sky130_fd_pr__pfet_01v8_hvt ad=0.0693 pd=0.75 as=0.0441 ps=0.63 w=0.42 l=0.15
X4 VPWR A a_183_297# VPB sky130_fd_pr__pfet_01v8_hvt ad=0.14825 pd=1.34 as=0.0693 ps=0.75 w=0.42 l=0.15
X5 a_29_53# B VGND VNB sky130_fd_pr__nfet_01v8 ad=0.0567 pd=0.69 as=0.0567 ps=0.69 w=0.42 l=0.15
X6 VGND C a_29_53# VNB sky130_fd_pr__nfet_01v8 ad=0.0567 pd=0.69 as=0.1092 ps=1.36 w=0.42 l=0.15
X7 VGND A a_29_53# VNB sky130_fd_pr__nfet_01v8 ad=0.10187 pd=0.99 as=0.0567 ps=0.69 w=0.42 l=0.15
.ends

.subckt sky130_fd_sc_hd__conb_1 LO HI VPB VNB VGND VPWR
R0 VPWR HI sky130_fd_pr__res_generic_po w=0.48 l=0.045
R1 LO VGND sky130_fd_pr__res_generic_po w=0.48 l=0.045
.ends

.subckt sky130_fd_sc_hd__o22a_1 VPB VNB VGND VPWR B2 A2 A1 B1 X
X0 a_78_199# B1 a_215_47# VNB sky130_fd_pr__nfet_01v8 ad=0.08775 pd=0.92 as=0.169 ps=1.82 w=0.65 l=0.15
X1 VPWR A1 a_493_297# VPB sky130_fd_pr__pfet_01v8_hvt ad=0.26 pd=2.52 as=0.105 ps=1.21 w=1 l=0.15
X2 a_493_297# A2 a_78_199# VPB sky130_fd_pr__pfet_01v8_hvt ad=0.105 pd=1.21 as=0.235 ps=1.47 w=1 l=0.15
X3 VPWR a_78_199# X VPB sky130_fd_pr__pfet_01v8_hvt ad=0.3725 pd=1.745 as=0.28 ps=2.56 w=1 l=0.15
X4 VGND A2 a_215_47# VNB sky130_fd_pr__nfet_01v8 ad=0.08775 pd=0.92 as=0.11375 ps=1 w=0.65 l=0.15
X5 a_78_199# B2 a_292_297# VPB sky130_fd_pr__pfet_01v8_hvt ad=0.235 pd=1.47 as=0.1175 ps=1.235 w=1 l=0.15
X6 a_215_47# A1 VGND VNB sky130_fd_pr__nfet_01v8 ad=0.169 pd=1.82 as=0.08775 ps=0.92 w=0.65 l=0.15
X7 a_215_47# B2 a_78_199# VNB sky130_fd_pr__nfet_01v8 ad=0.11375 pd=1 as=0.08775 ps=0.92 w=0.65 l=0.15
X8 a_292_297# B1 VPWR VPB sky130_fd_pr__pfet_01v8_hvt ad=0.1175 pd=1.235 as=0.3725 ps=1.745 w=1 l=0.15
X9 VGND a_78_199# X VNB sky130_fd_pr__nfet_01v8 ad=0.169 pd=1.82 as=0.169 ps=1.82 w=0.65 l=0.15
.ends

.subckt sky130_fd_sc_hd__a32oi_1 VGND VPWR VPB VNB B2 Y B1 A1 A2 A3
X0 VPWR A3 a_27_297# VPB sky130_fd_pr__pfet_01v8_hvt ad=0.26 pd=2.52 as=0.14 ps=1.28 w=1 l=0.15
X1 VGND A3 a_383_47# VNB sky130_fd_pr__nfet_01v8 ad=0.169 pd=1.82 as=0.10725 ps=0.98 w=0.65 l=0.15
X2 a_309_47# A1 Y VNB sky130_fd_pr__nfet_01v8 ad=0.0715 pd=0.87 as=0.15275 ps=1.12 w=0.65 l=0.15
X3 Y B1 a_109_47# VNB sky130_fd_pr__nfet_01v8 ad=0.15275 pd=1.12 as=0.07475 ps=0.88 w=0.65 l=0.15
X4 a_27_297# B1 Y VPB sky130_fd_pr__pfet_01v8_hvt ad=0.215 pd=1.43 as=0.135 ps=1.27 w=1 l=0.15
X5 a_383_47# A2 a_309_47# VNB sky130_fd_pr__nfet_01v8 ad=0.10725 pd=0.98 as=0.0715 ps=0.87 w=0.65 l=0.15
X6 a_27_297# A2 VPWR VPB sky130_fd_pr__pfet_01v8_hvt ad=0.14 pd=1.28 as=0.135 ps=1.27 w=1 l=0.15
X7 Y B2 a_27_297# VPB sky130_fd_pr__pfet_01v8_hvt ad=0.135 pd=1.27 as=0.26 ps=2.52 w=1 l=0.15
X8 VPWR A1 a_27_297# VPB sky130_fd_pr__pfet_01v8_hvt ad=0.135 pd=1.27 as=0.215 ps=1.43 w=1 l=0.15
X9 a_109_47# B2 VGND VNB sky130_fd_pr__nfet_01v8 ad=0.07475 pd=0.88 as=0.169 ps=1.82 w=0.65 l=0.15
.ends

.subckt sky130_fd_sc_hd__mux2_1 VGND VPWR VPB VNB X A1 S A0
X0 VPWR a_505_21# a_535_374# VPB sky130_fd_pr__pfet_01v8_hvt ad=0.0693 pd=0.75 as=0.0441 ps=0.63 w=0.42 l=0.15
X1 a_505_21# S VPWR VPB sky130_fd_pr__pfet_01v8_hvt ad=0.1176 pd=1.4 as=0.0693 ps=0.75 w=0.42 l=0.15
X2 a_218_374# S VPWR VPB sky130_fd_pr__pfet_01v8_hvt ad=0.07665 pd=0.785 as=0.15835 ps=1.395 w=0.42 l=0.15
X3 VGND a_505_21# a_439_47# VNB sky130_fd_pr__nfet_01v8 ad=0.1449 pd=1.11 as=0.0693 ps=0.75 w=0.42 l=0.15
X4 a_76_199# A0 a_218_374# VPB sky130_fd_pr__pfet_01v8_hvt ad=0.1932 pd=1.34 as=0.07665 ps=0.785 w=0.42 l=0.15
X5 a_505_21# S VGND VNB sky130_fd_pr__nfet_01v8 ad=0.1092 pd=1.36 as=0.1449 ps=1.11 w=0.42 l=0.15
X6 a_439_47# A0 a_76_199# VNB sky130_fd_pr__nfet_01v8 ad=0.0693 pd=0.75 as=0.09975 ps=0.895 w=0.42 l=0.15
X7 a_535_374# A1 a_76_199# VPB sky130_fd_pr__pfet_01v8_hvt ad=0.0441 pd=0.63 as=0.1932 ps=1.34 w=0.42 l=0.15
X8 a_76_199# A1 a_218_47# VNB sky130_fd_pr__nfet_01v8 ad=0.09975 pd=0.895 as=0.0693 ps=0.75 w=0.42 l=0.15
X9 a_218_47# S VGND VNB sky130_fd_pr__nfet_01v8 ad=0.0693 pd=0.75 as=0.11285 ps=1.045 w=0.42 l=0.15
X10 VPWR a_76_199# X VPB sky130_fd_pr__pfet_01v8_hvt ad=0.15835 pd=1.395 as=0.26 ps=2.52 w=1 l=0.15
X11 VGND a_76_199# X VNB sky130_fd_pr__nfet_01v8 ad=0.11285 pd=1.045 as=0.169 ps=1.82 w=0.65 l=0.15
.ends

.subckt sky130_fd_sc_hd__lpflow_isobufsrc_1 VPB VNB VGND VPWR A SLEEP X
X0 X a_74_47# a_265_297# VPB sky130_fd_pr__pfet_01v8_hvt ad=0.26 pd=2.52 as=0.105 ps=1.21 w=1 l=0.15
X1 VPWR A a_74_47# VPB sky130_fd_pr__pfet_01v8_hvt ad=0.1573 pd=1.39 as=0.1092 ps=1.36 w=0.42 l=0.15
X2 a_265_297# SLEEP VPWR VPB sky130_fd_pr__pfet_01v8_hvt ad=0.105 pd=1.21 as=0.1573 ps=1.39 w=1 l=0.15
X3 X SLEEP VGND VNB sky130_fd_pr__nfet_01v8 ad=0.08775 pd=0.92 as=0.10025 ps=0.985 w=0.65 l=0.15
X4 VGND A a_74_47# VNB sky130_fd_pr__nfet_01v8 ad=0.10025 pd=0.985 as=0.1092 ps=1.36 w=0.42 l=0.15
X5 VGND a_74_47# X VNB sky130_fd_pr__nfet_01v8 ad=0.169 pd=1.82 as=0.08775 ps=0.92 w=0.65 l=0.15
.ends

.subckt sky130_fd_sc_hd__a21boi_0 VNB VPB VPWR VGND A1 A2 B1_N Y
X0 a_300_369# A2 VPWR VPB sky130_fd_pr__pfet_01v8_hvt ad=0.1696 pd=1.81 as=0.0896 ps=0.92 w=0.64 l=0.15
X1 a_400_47# A1 Y VNB sky130_fd_pr__nfet_01v8 ad=0.0441 pd=0.63 as=0.1113 ps=0.95 w=0.42 l=0.15
X2 VGND A2 a_400_47# VNB sky130_fd_pr__nfet_01v8 ad=0.1113 pd=1.37 as=0.0441 ps=0.63 w=0.42 l=0.15
X3 VGND B1_N a_27_47# VNB sky130_fd_pr__nfet_01v8 ad=0.1302 pd=1.04 as=0.1113 ps=1.37 w=0.42 l=0.15
X4 VPWR B1_N a_27_47# VPB sky130_fd_pr__pfet_01v8_hvt ad=0.1113 pd=1.37 as=0.1113 ps=1.37 w=0.42 l=0.15
X5 Y a_27_47# VGND VNB sky130_fd_pr__nfet_01v8 ad=0.1113 pd=0.95 as=0.1302 ps=1.04 w=0.42 l=0.15
X6 a_300_369# a_27_47# Y VPB sky130_fd_pr__pfet_01v8_hvt ad=0.0896 pd=0.92 as=0.1696 ps=1.81 w=0.64 l=0.15
X7 VPWR A1 a_300_369# VPB sky130_fd_pr__pfet_01v8_hvt ad=0.0896 pd=0.92 as=0.0896 ps=0.92 w=0.64 l=0.15
.ends

.subckt sky130_fd_sc_hd__o32ai_1 VPB VNB VGND VPWR A1 A2 B1 Y B2 A3
X0 VGND A3 a_27_47# VNB sky130_fd_pr__nfet_01v8 ad=0.21937 pd=1.325 as=0.10075 ps=0.96 w=0.65 l=0.15
X1 a_27_47# A2 VGND VNB sky130_fd_pr__nfet_01v8 ad=0.08775 pd=0.92 as=0.21937 ps=1.325 w=0.65 l=0.15
X2 Y B2 a_109_297# VPB sky130_fd_pr__pfet_01v8_hvt ad=0.305 pd=1.61 as=0.105 ps=1.21 w=1 l=0.15
X3 a_333_297# A3 Y VPB sky130_fd_pr__pfet_01v8_hvt ad=0.245 pd=1.49 as=0.305 ps=1.61 w=1 l=0.15
X4 VGND A1 a_27_47# VNB sky130_fd_pr__nfet_01v8 ad=0.234 pd=2.02 as=0.08775 ps=0.92 w=0.65 l=0.15
X5 a_27_47# B2 Y VNB sky130_fd_pr__nfet_01v8 ad=0.10075 pd=0.96 as=0.10563 ps=0.975 w=0.65 l=0.15
X6 VPWR A1 a_461_297# VPB sky130_fd_pr__pfet_01v8_hvt ad=0.28 pd=2.56 as=0.135 ps=1.27 w=1 l=0.15
X7 a_109_297# B1 VPWR VPB sky130_fd_pr__pfet_01v8_hvt ad=0.105 pd=1.21 as=0.26 ps=2.52 w=1 l=0.15
X8 a_461_297# A2 a_333_297# VPB sky130_fd_pr__pfet_01v8_hvt ad=0.135 pd=1.27 as=0.245 ps=1.49 w=1 l=0.15
X9 Y B1 a_27_47# VNB sky130_fd_pr__nfet_01v8 ad=0.10563 pd=0.975 as=0.169 ps=1.82 w=0.65 l=0.15
.ends

.subckt sky130_fd_sc_hd__or4_1 VPWR VGND VPB VNB B D C A X
X0 a_27_297# B VGND VNB sky130_fd_pr__nfet_01v8 ad=0.0567 pd=0.69 as=0.0567 ps=0.69 w=0.42 l=0.15
X1 a_27_297# D VGND VNB sky130_fd_pr__nfet_01v8 ad=0.0693 pd=0.75 as=0.1092 ps=1.36 w=0.42 l=0.15
X2 a_277_297# B a_205_297# VPB sky130_fd_pr__pfet_01v8_hvt ad=0.0693 pd=0.75 as=0.0441 ps=0.63 w=0.42 l=0.15
X3 VPWR A a_277_297# VPB sky130_fd_pr__pfet_01v8_hvt ad=0.14825 pd=1.34 as=0.0693 ps=0.75 w=0.42 l=0.15
X4 X a_27_297# VGND VNB sky130_fd_pr__nfet_01v8 ad=0.1755 pd=1.84 as=0.10187 ps=0.99 w=0.65 l=0.15
X5 a_205_297# C a_109_297# VPB sky130_fd_pr__pfet_01v8_hvt ad=0.0441 pd=0.63 as=0.0693 ps=0.75 w=0.42 l=0.15
X6 X a_27_297# VPWR VPB sky130_fd_pr__pfet_01v8_hvt ad=0.27 pd=2.54 as=0.14825 ps=1.34 w=1 l=0.15
X7 VGND C a_27_297# VNB sky130_fd_pr__nfet_01v8 ad=0.0567 pd=0.69 as=0.0693 ps=0.75 w=0.42 l=0.15
X8 a_109_297# D a_27_297# VPB sky130_fd_pr__pfet_01v8_hvt ad=0.0693 pd=0.75 as=0.1092 ps=1.36 w=0.42 l=0.15
X9 VGND A a_27_297# VNB sky130_fd_pr__nfet_01v8 ad=0.10187 pd=0.99 as=0.0567 ps=0.69 w=0.42 l=0.15
.ends

.subckt sky130_fd_sc_hd__nor4bb_1 VNB VPB VGND VPWR A Y B D_N C_N
X0 Y B VGND VNB sky130_fd_pr__nfet_01v8 ad=0.08775 pd=0.92 as=0.10725 ps=0.98 w=0.65 l=0.15
X1 VGND a_27_410# Y VNB sky130_fd_pr__nfet_01v8 ad=0.10725 pd=0.98 as=0.08775 ps=0.92 w=0.65 l=0.15
X2 VGND C_N a_27_410# VNB sky130_fd_pr__nfet_01v8 ad=0.0609 pd=0.71 as=0.1092 ps=1.36 w=0.42 l=0.15
X3 VGND A Y VNB sky130_fd_pr__nfet_01v8 ad=0.169 pd=1.82 as=0.08775 ps=0.92 w=0.65 l=0.15
X4 VPWR C_N a_27_410# VPB sky130_fd_pr__pfet_01v8_hvt ad=0.1226 pd=1.32 as=0.1092 ps=1.36 w=0.42 l=0.15
X5 a_205_93# D_N VGND VNB sky130_fd_pr__nfet_01v8 ad=0.1092 pd=1.36 as=0.0609 ps=0.71 w=0.42 l=0.15
X6 VPWR A a_573_297# VPB sky130_fd_pr__pfet_01v8_hvt ad=0.26 pd=2.52 as=0.135 ps=1.27 w=1 l=0.15
X7 a_205_93# D_N VPWR VPB sky130_fd_pr__pfet_01v8_hvt ad=0.1085 pd=1.36 as=0.1226 ps=1.32 w=0.42 l=0.15
X8 a_477_297# a_27_410# a_393_297# VPB sky130_fd_pr__pfet_01v8_hvt ad=0.165 pd=1.33 as=0.135 ps=1.27 w=1 l=0.15
X9 a_573_297# B a_477_297# VPB sky130_fd_pr__pfet_01v8_hvt ad=0.135 pd=1.27 as=0.165 ps=1.33 w=1 l=0.15
X10 a_393_297# a_205_93# Y VPB sky130_fd_pr__pfet_01v8_hvt ad=0.135 pd=1.27 as=0.2559 ps=2.52 w=1 l=0.15
X11 Y a_205_93# VGND VNB sky130_fd_pr__nfet_01v8 ad=0.08775 pd=0.92 as=0.169 ps=1.82 w=0.65 l=0.15
.ends

.subckt sky130_fd_sc_hd__nor4b_1 VPB VNB VGND VPWR D_N C Y B A
X0 Y a_91_199# VGND VNB sky130_fd_pr__nfet_01v8 ad=0.08775 pd=0.92 as=0.182 ps=1.86 w=0.65 l=0.15
X1 Y B VGND VNB sky130_fd_pr__nfet_01v8 ad=0.08775 pd=0.92 as=0.10725 ps=0.98 w=0.65 l=0.15
X2 VGND C Y VNB sky130_fd_pr__nfet_01v8 ad=0.10725 pd=0.98 as=0.08775 ps=0.92 w=0.65 l=0.15
X3 a_91_199# D_N VGND VNB sky130_fd_pr__nfet_01v8 ad=0.1092 pd=1.36 as=0.10025 ps=0.985 w=0.42 l=0.15
X4 VGND A Y VNB sky130_fd_pr__nfet_01v8 ad=0.10025 pd=0.985 as=0.08775 ps=0.92 w=0.65 l=0.15
X5 VPWR A a_341_297# VPB sky130_fd_pr__pfet_01v8_hvt ad=0.14575 pd=1.335 as=0.135 ps=1.27 w=1 l=0.15
X6 a_245_297# C a_161_297# VPB sky130_fd_pr__pfet_01v8_hvt ad=0.165 pd=1.33 as=0.135 ps=1.27 w=1 l=0.15
X7 a_341_297# B a_245_297# VPB sky130_fd_pr__pfet_01v8_hvt ad=0.135 pd=1.27 as=0.165 ps=1.33 w=1 l=0.15
X8 a_91_199# D_N VPWR VPB sky130_fd_pr__pfet_01v8_hvt ad=0.1092 pd=1.36 as=0.14575 ps=1.335 w=0.42 l=0.15
X9 a_161_297# a_91_199# Y VPB sky130_fd_pr__pfet_01v8_hvt ad=0.135 pd=1.27 as=0.52 ps=3.04 w=1 l=0.15
.ends

.subckt sky130_fd_sc_hd__dfstp_2 VPB VNB VPWR VGND Q SET_B D CLK
X0 VGND a_652_21# a_586_47# VNB sky130_fd_pr__nfet_01v8 ad=0.0882 pd=0.84 as=0.06705 ps=0.75 w=0.42 l=0.15
X1 a_956_413# a_476_47# VPWR VPB sky130_fd_pr__pfet_01v8_hvt ad=0.0441 pd=0.63 as=0.0567 ps=0.69 w=0.42 l=0.15
X2 a_1136_413# a_193_47# a_1028_413# VPB sky130_fd_pr__pfet_01v8_hvt ad=0.0441 pd=0.63 as=0.0819 ps=0.81 w=0.42 l=0.15
X3 VPWR a_476_47# a_652_21# VPB sky130_fd_pr__pfet_01v8_hvt ad=0.0567 pd=0.69 as=0.0567 ps=0.69 w=0.42 l=0.15
X4 a_586_47# a_193_47# a_476_47# VNB sky130_fd_pr__nfet_01v8 ad=0.06705 pd=0.75 as=0.072 ps=0.76 w=0.36 l=0.15
X5 a_1228_47# a_27_47# a_1028_413# VNB sky130_fd_pr__nfet_01v8 ad=0.0441 pd=0.63 as=0.0735 ps=0.77 w=0.42 l=0.15
X6 VPWR CLK a_27_47# VPB sky130_fd_pr__pfet_01v8_hvt ad=0.0864 pd=0.91 as=0.1664 ps=1.8 w=0.64 l=0.15
X7 a_476_47# a_27_47# a_381_47# VNB sky130_fd_pr__nfet_01v8 ad=0.072 pd=0.76 as=0.0935 ps=0.965 w=0.36 l=0.15
X8 a_1056_47# a_476_47# VGND VNB sky130_fd_pr__nfet_01v8 ad=0.0441 pd=0.63 as=0.1092 ps=1.36 w=0.42 l=0.15
X9 a_381_47# D VPWR VPB sky130_fd_pr__pfet_01v8_hvt ad=0.12495 pd=1.175 as=0.2184 ps=2.2 w=0.84 l=0.15
X10 a_652_21# SET_B VPWR VPB sky130_fd_pr__pfet_01v8_hvt ad=0.0567 pd=0.69 as=0.0798 ps=0.8 w=0.42 l=0.15
X11 VPWR a_1602_47# Q VPB sky130_fd_pr__pfet_01v8_hvt ad=0.26 pd=2.52 as=0.135 ps=1.27 w=1 l=0.15
X12 a_562_413# a_27_47# a_476_47# VPB sky130_fd_pr__pfet_01v8_hvt ad=0.0945 pd=0.87 as=0.0567 ps=0.69 w=0.42 l=0.15
X13 VGND a_1028_413# a_1602_47# VNB sky130_fd_pr__nfet_01v8 ad=0.08775 pd=0.92 as=0.169 ps=1.82 w=0.65 l=0.15
X14 VGND a_1602_47# Q VNB sky130_fd_pr__nfet_01v8 ad=0.169 pd=1.82 as=0.08775 ps=0.92 w=0.65 l=0.15
X15 Q a_1602_47# VPWR VPB sky130_fd_pr__pfet_01v8_hvt ad=0.135 pd=1.27 as=0.135 ps=1.27 w=1 l=0.15
X16 a_1028_413# a_193_47# a_1056_47# VNB sky130_fd_pr__nfet_01v8 ad=0.0735 pd=0.77 as=0.0441 ps=0.63 w=0.42 l=0.15
X17 a_476_47# a_193_47# a_381_47# VPB sky130_fd_pr__pfet_01v8_hvt ad=0.0567 pd=0.69 as=0.12495 ps=1.175 w=0.42 l=0.15
X18 a_193_47# a_27_47# VGND VNB sky130_fd_pr__nfet_01v8 ad=0.1092 pd=1.36 as=0.0567 ps=0.69 w=0.42 l=0.15
X19 VPWR a_1028_413# a_1602_47# VPB sky130_fd_pr__pfet_01v8_hvt ad=0.135 pd=1.27 as=0.26 ps=2.52 w=1 l=0.15
X20 VPWR a_652_21# a_562_413# VPB sky130_fd_pr__pfet_01v8_hvt ad=0.0798 pd=0.8 as=0.0945 ps=0.87 w=0.42 l=0.15
X21 Q a_1602_47# VGND VNB sky130_fd_pr__nfet_01v8 ad=0.08775 pd=0.92 as=0.08775 ps=0.92 w=0.65 l=0.15
X22 a_1028_413# a_27_47# a_956_413# VPB sky130_fd_pr__pfet_01v8_hvt ad=0.0819 pd=0.81 as=0.0441 ps=0.63 w=0.42 l=0.15
X23 VPWR a_1178_261# a_1136_413# VPB sky130_fd_pr__pfet_01v8_hvt ad=0.1092 pd=1.36 as=0.0441 ps=0.63 w=0.42 l=0.15
X24 a_193_47# a_27_47# VPWR VPB sky130_fd_pr__pfet_01v8_hvt ad=0.1664 pd=1.8 as=0.0864 ps=0.91 w=0.64 l=0.15
X25 a_1178_261# a_1028_413# VPWR VPB sky130_fd_pr__pfet_01v8_hvt ad=0.2226 pd=2.21 as=0.12075 ps=1.165 w=0.84 l=0.15
X26 a_796_47# SET_B VGND VNB sky130_fd_pr__nfet_01v8 ad=0.0441 pd=0.63 as=0.0882 ps=0.84 w=0.42 l=0.15
X27 a_1300_47# a_1178_261# a_1228_47# VNB sky130_fd_pr__nfet_01v8 ad=0.0441 pd=0.63 as=0.0441 ps=0.63 w=0.42 l=0.15
X28 a_381_47# D VGND VNB sky130_fd_pr__nfet_01v8 ad=0.0935 pd=0.965 as=0.1664 ps=1.8 w=0.64 l=0.15
X29 a_1178_261# a_1028_413# VGND VNB sky130_fd_pr__nfet_01v8 ad=0.1404 pd=1.6 as=0.1137 ps=1.01 w=0.54 l=0.15
X30 a_652_21# a_476_47# a_796_47# VNB sky130_fd_pr__nfet_01v8 ad=0.1092 pd=1.36 as=0.0441 ps=0.63 w=0.42 l=0.15
X31 VPWR SET_B a_1028_413# VPB sky130_fd_pr__pfet_01v8_hvt ad=0.12075 pd=1.165 as=0.1092 ps=1.36 w=0.42 l=0.15
X32 VGND CLK a_27_47# VNB sky130_fd_pr__nfet_01v8 ad=0.0567 pd=0.69 as=0.1092 ps=1.36 w=0.42 l=0.15
X33 VGND SET_B a_1300_47# VNB sky130_fd_pr__nfet_01v8 ad=0.1137 pd=1.01 as=0.0441 ps=0.63 w=0.42 l=0.15
.ends

.subckt sky130_fd_sc_hd__and4b_1 VGND VPWR C A_N X D B VPB VNB
X0 a_297_47# a_27_47# a_193_413# VNB sky130_fd_pr__nfet_01v8 ad=0.0441 pd=0.63 as=0.1092 ps=1.36 w=0.42 l=0.15
X1 a_369_47# B a_297_47# VNB sky130_fd_pr__nfet_01v8 ad=0.0735 pd=0.77 as=0.0441 ps=0.63 w=0.42 l=0.15
X2 VPWR D a_193_413# VPB sky130_fd_pr__pfet_01v8_hvt ad=0.14075 pd=1.325 as=0.06615 ps=0.735 w=0.42 l=0.15
X3 X a_193_413# VGND VNB sky130_fd_pr__nfet_01v8 ad=0.169 pd=1.82 as=0.1034 ps=1 w=0.65 l=0.15
X4 VPWR A_N a_27_47# VPB sky130_fd_pr__pfet_01v8_hvt ad=0.0567 pd=0.69 as=0.1092 ps=1.36 w=0.42 l=0.15
X5 VGND D a_469_47# VNB sky130_fd_pr__nfet_01v8 ad=0.1034 pd=1 as=0.0609 ps=0.71 w=0.42 l=0.15
X6 X a_193_413# VPWR VPB sky130_fd_pr__pfet_01v8_hvt ad=0.26 pd=2.52 as=0.14075 ps=1.325 w=1 l=0.15
X7 VPWR B a_193_413# VPB sky130_fd_pr__pfet_01v8_hvt ad=0.1281 pd=1.03 as=0.0987 ps=0.89 w=0.42 l=0.15
X8 a_193_413# C VPWR VPB sky130_fd_pr__pfet_01v8_hvt ad=0.06615 pd=0.735 as=0.1281 ps=1.03 w=0.42 l=0.15
X9 a_193_413# a_27_47# VPWR VPB sky130_fd_pr__pfet_01v8_hvt ad=0.0987 pd=0.89 as=0.0567 ps=0.69 w=0.42 l=0.15
X10 a_469_47# C a_369_47# VNB sky130_fd_pr__nfet_01v8 ad=0.0609 pd=0.71 as=0.0735 ps=0.77 w=0.42 l=0.15
X11 VGND A_N a_27_47# VNB sky130_fd_pr__nfet_01v8 ad=0.1092 pd=1.36 as=0.1092 ps=1.36 w=0.42 l=0.15
.ends

.subckt sky130_fd_sc_hd__and2_0 VNB VPB VPWR VGND X B A
X0 VPWR B a_40_47# VPB sky130_fd_pr__pfet_01v8_hvt ad=0.1841 pd=1.26 as=0.0609 ps=0.71 w=0.42 l=0.15
X1 X a_40_47# VPWR VPB sky130_fd_pr__pfet_01v8_hvt ad=0.1696 pd=1.81 as=0.1841 ps=1.26 w=0.64 l=0.15
X2 VGND B a_123_47# VNB sky130_fd_pr__nfet_01v8 ad=0.0966 pd=0.88 as=0.0441 ps=0.63 w=0.42 l=0.15
X3 X a_40_47# VGND VNB sky130_fd_pr__nfet_01v8 ad=0.1113 pd=1.37 as=0.0966 ps=0.88 w=0.42 l=0.15
X4 a_123_47# A a_40_47# VNB sky130_fd_pr__nfet_01v8 ad=0.0441 pd=0.63 as=0.1113 ps=1.37 w=0.42 l=0.15
X5 a_40_47# A VPWR VPB sky130_fd_pr__pfet_01v8_hvt ad=0.0609 pd=0.71 as=0.1113 ps=1.37 w=0.42 l=0.15
.ends

.subckt sky130_fd_sc_hd__a22o_1 VPWR VGND VPB VNB B1 A1 A2 X B2
X0 VPWR A2 a_109_297# VPB sky130_fd_pr__pfet_01v8_hvt ad=0.155 pd=1.31 as=0.16 ps=1.32 w=1 l=0.15
X1 a_27_297# B1 a_109_47# VNB sky130_fd_pr__nfet_01v8 ad=0.169 pd=1.82 as=0.07475 ps=0.88 w=0.65 l=0.15
X2 VGND A2 a_373_47# VNB sky130_fd_pr__nfet_01v8 ad=0.10075 pd=0.96 as=0.11375 ps=1 w=0.65 l=0.15
X3 X a_27_297# VPWR VPB sky130_fd_pr__pfet_01v8_hvt ad=0.26 pd=2.52 as=0.155 ps=1.31 w=1 l=0.15
X4 a_27_297# B1 a_109_297# VPB sky130_fd_pr__pfet_01v8_hvt ad=0.25285 pd=2.52 as=0.135 ps=1.27 w=1 l=0.15
X5 a_109_297# A1 VPWR VPB sky130_fd_pr__pfet_01v8_hvt ad=0.16 pd=1.32 as=0.2529 ps=2.52 w=1 l=0.15
X6 a_373_47# A1 a_27_297# VNB sky130_fd_pr__nfet_01v8 ad=0.11375 pd=1 as=0.169 ps=1.82 w=0.65 l=0.15
X7 X a_27_297# VGND VNB sky130_fd_pr__nfet_01v8 ad=0.169 pd=1.82 as=0.10075 ps=0.96 w=0.65 l=0.15
X8 a_109_297# B2 a_27_297# VPB sky130_fd_pr__pfet_01v8_hvt ad=0.135 pd=1.27 as=0.26 ps=2.52 w=1 l=0.15
X9 a_109_47# B2 VGND VNB sky130_fd_pr__nfet_01v8 ad=0.07475 pd=0.88 as=0.169 ps=1.82 w=0.65 l=0.15
.ends

.subckt sky130_fd_sc_hd__clkinv_1 VPB VNB VGND VPWR A Y
X0 Y A VPWR VPB sky130_fd_pr__pfet_01v8_hvt ad=0.1134 pd=1.11 as=0.2184 ps=2.2 w=0.84 l=0.15
X1 VGND A Y VNB sky130_fd_pr__nfet_01v8 ad=0.1197 pd=1.41 as=0.1092 ps=1.36 w=0.42 l=0.15
X2 VPWR A Y VPB sky130_fd_pr__pfet_01v8_hvt ad=0.2352 pd=2.24 as=0.1134 ps=1.11 w=0.84 l=0.15
.ends

.subckt sky130_fd_sc_hd__xnor2_1 VGND VPWR B Y A VPB VNB
X0 a_377_297# A VPWR VPB sky130_fd_pr__pfet_01v8_hvt ad=0.105 pd=1.21 as=0.365 ps=1.73 w=1 l=0.15
X1 a_47_47# B VPWR VPB sky130_fd_pr__pfet_01v8_hvt ad=0.135 pd=1.27 as=0.3 ps=2.6 w=1 l=0.15
X2 a_129_47# B a_47_47# VNB sky130_fd_pr__nfet_01v8 ad=0.06825 pd=0.86 as=0.169 ps=1.82 w=0.65 l=0.15
X3 a_285_47# B VGND VNB sky130_fd_pr__nfet_01v8 ad=0.08775 pd=0.92 as=0.169 ps=1.82 w=0.65 l=0.15
X4 Y a_47_47# a_285_47# VNB sky130_fd_pr__nfet_01v8 ad=0.195 pd=1.9 as=0.08775 ps=0.92 w=0.65 l=0.15
X5 VGND A a_129_47# VNB sky130_fd_pr__nfet_01v8 ad=0.08775 pd=0.92 as=0.06825 ps=0.86 w=0.65 l=0.15
X6 VPWR A a_47_47# VPB sky130_fd_pr__pfet_01v8_hvt ad=0.365 pd=1.73 as=0.135 ps=1.27 w=1 l=0.15
X7 VPWR a_47_47# Y VPB sky130_fd_pr__pfet_01v8_hvt ad=0.36 pd=2.72 as=0.165 ps=1.33 w=1 l=0.15
X8 Y B a_377_297# VPB sky130_fd_pr__pfet_01v8_hvt ad=0.165 pd=1.33 as=0.105 ps=1.21 w=1 l=0.15
X9 a_285_47# A VGND VNB sky130_fd_pr__nfet_01v8 ad=0.169 pd=1.82 as=0.08775 ps=0.92 w=0.65 l=0.15
.ends

.subckt tt_um_dusterthefirst_project VGND VPWR clk ena rst_n ui_in[0] ui_in[1] ui_in[2]
+ ui_in[3] ui_in[4] ui_in[5] ui_in[6] ui_in[7] uio_in[0] uio_in[1] uio_in[2] uio_in[3]
+ uio_in[4] uio_in[5] uio_in[6] uio_in[7] uio_oe[0] uio_oe[1] uio_oe[2] uio_oe[3]
+ uio_oe[4] uio_oe[5] uio_oe[6] uio_oe[7] uio_out[0] uio_out[1] uio_out[2] uio_out[3]
+ uio_out[4] uio_out[5] uio_out[6] uio_out[7] uo_out[0] uo_out[1] uo_out[2] uo_out[3]
+ uo_out[4] uo_out[5] uo_out[6] uo_out[7]
X_0985_ VGND VPWR VPWR VGND _0985_/CLK _0985_/D _0985_/RESET_B _0985_/Q sky130_fd_sc_hd__dfrtp_1
X_0770_ VPWR VGND VGND VPWR _0770_/A _0770_/Y _0770_/B sky130_fd_sc_hd__nand2_1
X_0968_ VGND VPWR VPWR VGND _0968_/CLK _0968_/D _0968_/RESET_B _0968_/Q sky130_fd_sc_hd__dfrtp_1
X_0899_ VPWR VGND VGND VPWR _0899_/A _0899_/Y _0899_/B sky130_fd_sc_hd__nand2_1
X_0822_ VPWR VGND VGND VPWR _0822_/A _0822_/Y _0822_/B sky130_fd_sc_hd__nand2_1
X_0684_ VGND VPWR VGND VPWR _0684_/B1 _0684_/A1 _0684_/Y _0684_/A2 sky130_fd_sc_hd__o21ai_0
X_0753_ VPWR VGND VGND VPWR _0753_/A _0753_/Y _0753_/B sky130_fd_sc_hd__nand2_1
X_1021_ _1021_/Q _1021_/CLK _1021_/D VPWR VGND VPWR VGND sky130_fd_sc_hd__dfxtp_1
X_0805_ VPWR VGND VGND VPWR _0805_/A _0805_/Y _0805_/B sky130_fd_sc_hd__nand2_1
X_0736_ VPWR VGND VGND VPWR _0736_/A _0736_/Y _0736_/B sky130_fd_sc_hd__nand2_1
X_0667_ VPWR VGND VGND VPWR _0667_/A _0667_/Y _0667_/B sky130_fd_sc_hd__nand2_1
X_0598_ VPWR VGND VGND VPWR _0598_/Y _0598_/D _0598_/C _0598_/B _0598_/A sky130_fd_sc_hd__nor4_1
X_0521_ VPWR VGND VGND VPWR _0521_/A1 _0521_/A2 _0521_/B1 _0521_/X sky130_fd_sc_hd__o21a_1
X_1004_ VGND VPWR VPWR VGND _1004_/CLK _1004_/D _1004_/RESET_B _1004_/Q sky130_fd_sc_hd__dfrtp_1
X_0719_ VPWR VGND VGND VPWR _0719_/A _0719_/Y _0719_/B sky130_fd_sc_hd__nand2_1
X_0504_ VGND VPWR VPWR VGND _0504_/C2 _0504_/C1 _0504_/B1 _0504_/A2 _0504_/A1 _0504_/Y
+ _0504_/B2 sky130_fd_sc_hd__a222oi_1
Xclkbuf_3_6__f_clk VGND VPWR VGND VPWR clkbuf_3_6__f_clk/A clkbuf_3_6__f_clk/X sky130_fd_sc_hd__clkbuf_16
X_0984_ VGND VPWR VPWR VGND _0984_/CLK _0984_/D _0984_/RESET_B _0984_/Q sky130_fd_sc_hd__dfrtp_1
X_0967_ VGND VPWR VPWR VGND _0967_/CLK _0967_/D _0967_/RESET_B _0967_/Q sky130_fd_sc_hd__dfrtp_1
X_0898_ VPWR VGND VGND VPWR _0898_/A _0898_/Y _0898_/B sky130_fd_sc_hd__nand2_1
X_0752_ VPWR VGND VGND VPWR _0752_/A _0752_/Y _0752_/B sky130_fd_sc_hd__nand2_1
X_0821_ VPWR VGND VGND VPWR _0821_/A _0821_/Y _0821_/B sky130_fd_sc_hd__nand2_1
X_0683_ VPWR VGND VGND VPWR _0683_/A _0683_/Y _0683_/B sky130_fd_sc_hd__nand2_1
X_1020_ _1020_/Q _1020_/CLK _1020_/D VPWR VGND VPWR VGND sky130_fd_sc_hd__dfxtp_1
X_0735_ VPWR VGND VGND VPWR _0735_/A _0735_/Y _0735_/B sky130_fd_sc_hd__nand2_1
X_0804_ VPWR VGND VGND VPWR _0804_/A _0804_/Y _0804_/B sky130_fd_sc_hd__nand2_1
X_0666_ VGND VPWR VGND VPWR _0666_/B1 _0666_/A1 _0666_/Y _0666_/A2 sky130_fd_sc_hd__o21ai_0
X_0597_ VPWR VGND VGND VPWR _0597_/Y _0597_/C _0597_/B _0597_/D _0597_/A_N sky130_fd_sc_hd__nand4b_1
X_0520_ VPWR VGND VGND VPWR _0520_/A _0520_/B _0520_/Y _0520_/C sky130_fd_sc_hd__nand3_1
X_1003_ VGND VPWR VPWR VGND _1003_/CLK _1003_/D _1003_/RESET_B _1003_/Q sky130_fd_sc_hd__dfrtp_1
X_0718_ VPWR VGND VGND VPWR _0718_/A _0718_/Y _0718_/B sky130_fd_sc_hd__nand2_1
X_0649_ VPWR VGND VGND VPWR _0649_/A _0649_/Y _0649_/B sky130_fd_sc_hd__nand2_1
X_0503_ VGND VPWR VPWR VGND _0503_/C2 _0503_/C1 _0503_/B1 _0503_/A2 _0503_/A1 _0503_/Y
+ _0503_/B2 sky130_fd_sc_hd__a222oi_1
X_0983_ VGND VPWR VPWR VGND _0983_/CLK _0983_/D _0983_/RESET_B _0983_/Q sky130_fd_sc_hd__dfrtp_1
X_0897_ VPWR VGND VPWR VGND _0897_/A2 _0897_/A1 _0897_/B1 _0897_/Y sky130_fd_sc_hd__a21oi_1
X_0966_ VGND VPWR VPWR VGND _0966_/CLK _0966_/D _0966_/RESET_B _0966_/Q sky130_fd_sc_hd__dfrtp_1
X_0751_ VPWR VGND VGND VPWR _0751_/A _0751_/Y _0751_/B sky130_fd_sc_hd__nand2_1
X_0820_ VPWR VGND VGND VPWR _0820_/A _0820_/Y _0820_/B sky130_fd_sc_hd__nand2_1
X_0682_ VPWR VGND VGND VPWR _0682_/A _0682_/Y _0682_/B sky130_fd_sc_hd__nand2_1
X_0949_ VGND VPWR VPWR VGND _0949_/CLK _0949_/D _0949_/RESET_B _0949_/Q sky130_fd_sc_hd__dfrtp_1
X_0734_ VPWR VGND VGND VPWR _0734_/A _0734_/Y _0734_/B sky130_fd_sc_hd__nand2_1
X_0665_ VPWR VGND VGND VPWR _0665_/A _0665_/Y _0665_/B sky130_fd_sc_hd__nand2_1
X_0803_ VPWR VGND VGND VPWR _0803_/A _0803_/Y _0803_/B sky130_fd_sc_hd__nand2_1
X_0596_ VPWR VGND VPWR VGND _0596_/B _0596_/C _0596_/A _0596_/X _0596_/D_N sky130_fd_sc_hd__or4b_1
X_1002_ VGND VPWR VPWR VGND _1002_/CLK _1002_/D _1002_/RESET_B _1002_/Q sky130_fd_sc_hd__dfrtp_1
X_0717_ VPWR VGND VGND VPWR _0717_/A _0717_/Y _0717_/B sky130_fd_sc_hd__nand2_1
X_0648_ VGND VPWR VGND VPWR _0648_/B1 _0648_/A1 _0648_/Y _0648_/A2 sky130_fd_sc_hd__o21ai_0
X_0579_ VPWR VGND VGND VPWR _0579_/C _0579_/B _0579_/A _0579_/Y sky130_fd_sc_hd__nor3_1
X_0502_ VPWR VGND VGND VPWR _0502_/A _0502_/Y _0502_/B sky130_fd_sc_hd__nand2_1
X_0982_ VGND VPWR VPWR VGND _0982_/CLK _0982_/D _0982_/RESET_B _0982_/Q sky130_fd_sc_hd__dfrtp_1
X_0896_ VPWR VGND VGND VPWR _0896_/C _0896_/B _0896_/A _0896_/Y sky130_fd_sc_hd__nor3_1
X_0965_ VGND VPWR VPWR VGND _0965_/CLK _0965_/D _0965_/RESET_B _0965_/Q sky130_fd_sc_hd__dfrtp_1
X_0681_ VPWR VGND VGND VPWR _0681_/A _0681_/Y _0681_/B sky130_fd_sc_hd__nand2_1
X_0750_ VGND VPWR VGND VPWR _0750_/B1 _0750_/A1 _0750_/Y _0750_/A2 sky130_fd_sc_hd__o21ai_0
X_0948_ VGND VPWR VPWR VGND _0948_/CLK _0948_/D _0948_/RESET_B _0948_/Q sky130_fd_sc_hd__dfrtp_1
X_0879_ VGND VPWR VGND VPWR _0879_/B1 _0879_/A1 _0879_/Y _0879_/A2 sky130_fd_sc_hd__o21ai_0
X_0802_ VPWR VGND VGND VPWR _0802_/A _0802_/Y _0802_/B sky130_fd_sc_hd__nand2_1
X_0733_ VPWR VGND VGND VPWR _0733_/A _0733_/Y _0733_/B sky130_fd_sc_hd__nand2_1
X_0664_ VPWR VGND VGND VPWR _0664_/A _0664_/Y _0664_/B sky130_fd_sc_hd__nand2_1
X_0595_ VPWR VGND VPWR VGND _0595_/B _0595_/C _0595_/A _0595_/X _0595_/D_N sky130_fd_sc_hd__or4b_1
X_1001_ VGND VPWR VPWR VGND _1001_/CLK _1001_/D _1001_/RESET_B _1001_/Q sky130_fd_sc_hd__dfrtp_1
X_0716_ VPWR VGND VGND VPWR _0716_/A _0716_/Y _0716_/B sky130_fd_sc_hd__nand2_1
X_0647_ VPWR VGND VGND VPWR _0647_/A _0647_/Y _0647_/B sky130_fd_sc_hd__nand2_1
X_0578_ VPWR VGND VGND VPWR _0578_/A _0578_/Y _0578_/B sky130_fd_sc_hd__nand2_1
X_0501_ VPWR VGND VPWR VGND _0501_/B2 _0501_/B1 _0501_/Y _0501_/A1 _0501_/A2 sky130_fd_sc_hd__a22oi_1
X_0981_ VGND VPWR VPWR VGND _0981_/CLK _0981_/D _0981_/RESET_B _0981_/Q sky130_fd_sc_hd__dfrtp_1
X_0964_ VGND VPWR VPWR VGND _0964_/CLK _0964_/D _0964_/RESET_B _0964_/Q sky130_fd_sc_hd__dfrtp_1
X_0895_ VGND VPWR VGND VPWR _0895_/A1 _0895_/A2 _0895_/A3 _0895_/A4 _0895_/Y _0895_/B1
+ sky130_fd_sc_hd__o41ai_1
X_0680_ VPWR VGND VGND VPWR _0680_/A _0680_/Y _0680_/B sky130_fd_sc_hd__nand2_1
X_0947_ VGND VPWR VPWR VGND _0947_/CLK _0947_/D _0947_/RESET_B _0947_/Q sky130_fd_sc_hd__dfrtp_1
X_0878_ VPWR VGND VGND VPWR _0878_/A _0878_/Y _0878_/B sky130_fd_sc_hd__nand2_1
X_0801_ VGND VPWR VGND VPWR _0801_/B1 _0801_/A1 _0801_/Y _0801_/A2 sky130_fd_sc_hd__o21ai_0
X_0732_ VPWR VGND VGND VPWR _0732_/A _0732_/Y _0732_/B sky130_fd_sc_hd__nand2_1
X_0594_ VPWR VGND VGND VPWR _0594_/Y _0594_/C _0594_/B _0594_/D _0594_/A_N sky130_fd_sc_hd__nand4b_1
X_0663_ VGND VPWR VGND VPWR _0663_/B1 _0663_/A1 _0663_/Y _0663_/A2 sky130_fd_sc_hd__o21ai_0
X_1000_ VGND VPWR VPWR VGND _1000_/CLK _1000_/D _1000_/RESET_B _1000_/Q sky130_fd_sc_hd__dfrtp_1
X_0715_ VPWR VGND VGND VPWR _0715_/A _0715_/Y _0715_/B sky130_fd_sc_hd__nand2_1
X_0646_ VPWR VGND VGND VPWR _0646_/A _0646_/Y _0646_/B sky130_fd_sc_hd__nand2_1
X_0577_ VPWR VGND VGND VPWR _0577_/C _0577_/B _0577_/A _0577_/Y sky130_fd_sc_hd__nor3_1
Xclkbuf_3_1__f_clk VGND VPWR VGND VPWR clkbuf_3_1__f_clk/A clkbuf_3_1__f_clk/X sky130_fd_sc_hd__clkbuf_16
X_0500_ VGND VPWR VPWR VGND _0500_/C2 _0500_/C1 _0500_/B1 _0500_/A2 _0500_/A1 _0500_/Y
+ _0500_/B2 sky130_fd_sc_hd__a222oi_1
X_0629_ VPWR VGND VGND VPWR _0629_/A _0629_/Y _0629_/B sky130_fd_sc_hd__nand2_1
X_0980_ VGND VPWR VPWR VGND _0980_/CLK _0980_/D _0980_/RESET_B _0980_/Q sky130_fd_sc_hd__dfrtp_1
X_0894_ VPWR VGND VGND VPWR _0894_/A _0894_/Y _0894_/B sky130_fd_sc_hd__nand2_1
X_0963_ VGND VPWR VPWR VGND _0963_/CLK _0963_/D _0963_/RESET_B _0963_/Q sky130_fd_sc_hd__dfrtp_1
X_0877_ VPWR VGND VGND VPWR _0877_/A _0877_/Y _0877_/B sky130_fd_sc_hd__nand2_1
X_0946_ VGND VPWR VPWR VGND _0946_/CLK _0946_/D _0946_/RESET_B _0946_/Q sky130_fd_sc_hd__dfrtp_1
X_0731_ VPWR VGND VGND VPWR _0731_/A _0731_/Y _0731_/B sky130_fd_sc_hd__nand2_1
X_0800_ VPWR VGND VGND VPWR _0800_/A _0800_/Y _0800_/B sky130_fd_sc_hd__nand2_1
X_0662_ VPWR VGND VGND VPWR _0662_/A _0662_/Y _0662_/B sky130_fd_sc_hd__nand2_1
X_0593_ VPWR VGND VGND VPWR _0593_/Y _0593_/D _0593_/C _0593_/B _0593_/A sky130_fd_sc_hd__nor4_1
X_0929_ VGND VPWR VPWR VGND _0929_/CLK _0929_/D _0929_/RESET_B _0929_/Q sky130_fd_sc_hd__dfrtp_1
X_0714_ VGND VPWR VGND VPWR _0714_/B1 _0714_/A1 _0714_/Y _0714_/A2 sky130_fd_sc_hd__o21ai_0
X_0645_ VGND VPWR VGND VPWR _0645_/B1 _0645_/A1 _0645_/Y _0645_/A2 sky130_fd_sc_hd__o21ai_0
X_0576_ VPWR VGND VGND VPWR _0576_/A _0576_/Y _0576_/B sky130_fd_sc_hd__nand2_1
XPHY_0 VPWR VGND VPWR VGND sky130_fd_sc_hd__decap_3
X_0628_ VPWR VGND VGND VPWR _0628_/A _0628_/Y _0628_/B sky130_fd_sc_hd__nand2_1
X_0559_ VPWR VGND VGND VPWR _0559_/A _0559_/B _0559_/Y _0559_/C sky130_fd_sc_hd__nand3_1
X_0893_ VPWR VGND VGND VPWR _0893_/X _0893_/SLEEP _0893_/A sky130_fd_sc_hd__lpflow_inputiso1p_1
X_0962_ VGND VPWR VPWR VGND _0962_/CLK _0962_/D _0962_/RESET_B _0962_/Q sky130_fd_sc_hd__dfrtp_1
X_0876_ VPWR VGND VGND VPWR _0876_/A _0876_/Y _0876_/B sky130_fd_sc_hd__nand2_1
X_0945_ VGND VPWR VPWR VGND _0945_/CLK _0945_/D _0945_/RESET_B _0945_/Q sky130_fd_sc_hd__dfrtp_1
X_0730_ VPWR VGND VGND VPWR _0730_/A _0730_/Y _0730_/B sky130_fd_sc_hd__nand2_1
X_0661_ VPWR VGND VGND VPWR _0661_/A _0661_/Y _0661_/B sky130_fd_sc_hd__nand2_1
X_0592_ VPWR VGND VPWR VGND _0592_/A _0592_/C _0592_/D _0592_/Y _0592_/B sky130_fd_sc_hd__nand4_1
X_0928_ VGND VPWR VPWR VGND _0928_/CLK _0928_/D _0928_/RESET_B _0928_/Q sky130_fd_sc_hd__dfrtp_1
X_0859_ VPWR VGND VGND VPWR _0859_/A _0859_/Y _0859_/B sky130_fd_sc_hd__nand2_1
X_0713_ VPWR VGND VGND VPWR _0713_/A _0713_/Y _0713_/B sky130_fd_sc_hd__nand2_1
X_0644_ VPWR VGND VGND VPWR _0644_/A _0644_/Y _0644_/B sky130_fd_sc_hd__nand2_1
X_0575_ VPWR VGND VGND VPWR _0575_/C _0575_/B _0575_/A _0575_/Y sky130_fd_sc_hd__nor3_1
XPHY_1 VPWR VGND VPWR VGND sky130_fd_sc_hd__decap_3
X_0627_ VGND VPWR VGND VPWR _0627_/B1 _0627_/A1 _0627_/Y _0627_/A2 sky130_fd_sc_hd__o21ai_0
X_0558_ VGND VPWR VPWR VGND _0558_/C2 _0558_/C1 _0558_/B1 _0558_/A2 _0558_/A1 _0558_/Y
+ _0558_/B2 sky130_fd_sc_hd__a222oi_1
X_0489_ VPWR VGND VGND VPWR _0489_/C _0489_/B _0489_/A _0489_/Y sky130_fd_sc_hd__nor3_1
X_0961_ VGND VPWR VPWR VGND _0961_/CLK _0961_/D _0961_/RESET_B _0961_/Q sky130_fd_sc_hd__dfrtp_1
X_0892_ VPWR VGND VPWR VGND _0892_/A2 _0892_/A1 _0892_/B1 _0892_/X sky130_fd_sc_hd__a21o_1
Xclkbuf_3_7__f_clk VGND VPWR VGND VPWR clkbuf_3_7__f_clk/A clkbuf_3_7__f_clk/X sky130_fd_sc_hd__clkbuf_16
X_0944_ VGND VPWR VPWR VGND _0944_/CLK _0944_/D _0944_/RESET_B _0944_/Q sky130_fd_sc_hd__dfrtp_1
X_0875_ VPWR VGND VGND VPWR _0875_/A _0875_/Y _0875_/B sky130_fd_sc_hd__nand2_1
X_0660_ VGND VPWR VGND VPWR _0660_/B1 _0660_/A1 _0660_/Y _0660_/A2 sky130_fd_sc_hd__o21ai_0
X_0591_ VPWR VGND VPWR VGND _0591_/A _0591_/C _0591_/D _0591_/Y _0591_/B sky130_fd_sc_hd__nand4_1
X_0927_ VGND VPWR VPWR VGND _0927_/CLK _0927_/D _0927_/RESET_B _0927_/Q sky130_fd_sc_hd__dfrtp_1
X_0789_ VPWR VGND VGND VPWR _0789_/A _0789_/Y _0789_/B sky130_fd_sc_hd__nand2_1
X_0858_ VPWR VGND VGND VPWR _0858_/A _0858_/Y _0858_/B sky130_fd_sc_hd__nand2_1
X_0712_ VPWR VGND VGND VPWR _0712_/A _0712_/Y _0712_/B sky130_fd_sc_hd__nand2_1
X_0643_ VPWR VGND VGND VPWR _0643_/A _0643_/Y _0643_/B sky130_fd_sc_hd__nand2_1
X_0574_ VPWR VGND VGND VPWR _0574_/A _0574_/Y _0574_/B sky130_fd_sc_hd__nand2_1
Xclkbuf_0_clk VGND VPWR VGND VPWR clkbuf_0_clk/A clkbuf_0_clk/X sky130_fd_sc_hd__clkbuf_16
XPHY_2 VPWR VGND VPWR VGND sky130_fd_sc_hd__decap_3
X_0626_ VPWR VGND VGND VPWR _0626_/A _0626_/Y _0626_/B sky130_fd_sc_hd__nand2_1
X_0557_ VGND VPWR VPWR VGND _0557_/C2 _0557_/C1 _0557_/B1 _0557_/A2 _0557_/A1 _0557_/Y
+ _0557_/B2 sky130_fd_sc_hd__a222oi_1
X_0488_ VPWR VGND VGND VPWR _0488_/A _0488_/Y _0488_/B sky130_fd_sc_hd__nand2_1
X_0609_ VGND VPWR VGND VPWR _0609_/B1 _0609_/A1 _0609_/Y _0609_/A2 sky130_fd_sc_hd__o21ai_0
X_0960_ VGND VPWR VPWR VGND _0960_/CLK _0960_/D _0960_/RESET_B _0960_/Q sky130_fd_sc_hd__dfrtp_1
X_0891_ VGND VPWR VGND VPWR _0891_/B1 _0891_/A1 _0891_/Y _0891_/A2 sky130_fd_sc_hd__o21ai_0
X_0874_ VPWR VGND VGND VPWR _0874_/A _0874_/Y _0874_/B sky130_fd_sc_hd__nand2_1
X_0943_ VGND VPWR VPWR VGND _0943_/CLK _0943_/D _0943_/RESET_B _0943_/Q sky130_fd_sc_hd__dfrtp_1
X_0590_ VPWR VGND VPWR VGND _0590_/A _0590_/C _0590_/D _0590_/Y _0590_/B sky130_fd_sc_hd__nand4_1
X_0926_ VGND VPWR VPWR VGND _0926_/CLK _0926_/D _0926_/RESET_B _0926_/Q sky130_fd_sc_hd__dfrtp_1
X_0857_ VPWR VGND VGND VPWR _0857_/A _0857_/Y _0857_/B sky130_fd_sc_hd__nand2_1
X_0788_ VPWR VGND VGND VPWR _0788_/A _0788_/Y _0788_/B sky130_fd_sc_hd__nand2_1
X_0711_ VPWR VGND VGND VPWR _0711_/A _0711_/Y _0711_/B sky130_fd_sc_hd__nand2_1
X_0642_ VGND VPWR VGND VPWR _0642_/B1 _0642_/A1 _0642_/Y _0642_/A2 sky130_fd_sc_hd__o21ai_0
X_0573_ VPWR VGND VGND VPWR _0573_/C _0573_/B _0573_/A _0573_/Y sky130_fd_sc_hd__nor3_1
X_0909_ VGND VPWR VGND VPWR _0909_/B1 _0909_/A1 _0909_/Y _0909_/A2 sky130_fd_sc_hd__o21ai_0
XPHY_3 VPWR VGND VPWR VGND sky130_fd_sc_hd__decap_3
X_0625_ VPWR VGND VGND VPWR _0625_/A _0625_/Y _0625_/B sky130_fd_sc_hd__nand2_1
X_0487_ VPWR VGND VGND VPWR _0487_/A _0487_/B _0487_/Y sky130_fd_sc_hd__nor2_1
X_0556_ VPWR VGND VGND VPWR _0556_/A _0556_/Y _0556_/B sky130_fd_sc_hd__nand2_1
X_0608_ VPWR VGND VGND VPWR _0608_/A _0608_/Y _0608_/B sky130_fd_sc_hd__nand2_1
X_0539_ VGND VPWR VPWR VGND _0539_/C2 _0539_/C1 _0539_/B1 _0539_/A2 _0539_/A1 _0539_/Y
+ _0539_/B2 sky130_fd_sc_hd__a222oi_1
X_0890_ VPWR VGND VGND VPWR _0890_/A _0890_/Y _0890_/B sky130_fd_sc_hd__nand2_1
X_0873_ VGND VPWR VGND VPWR _0873_/B1 _0873_/A1 _0873_/Y _0873_/A2 sky130_fd_sc_hd__o21ai_0
X_0942_ VGND VPWR VPWR VGND _0942_/CLK _0942_/D _0942_/RESET_B _0942_/Q sky130_fd_sc_hd__dfrtp_1
X_0925_ VGND VPWR VPWR VGND _0925_/CLK _0925_/D _0925_/RESET_B _0925_/Q sky130_fd_sc_hd__dfrtp_1
X_0787_ VPWR VGND VGND VPWR _0787_/A _0787_/Y _0787_/B sky130_fd_sc_hd__nand2_1
X_0856_ VPWR VGND VGND VPWR _0856_/A _0856_/Y _0856_/B sky130_fd_sc_hd__nand2_1
X_0710_ VPWR VGND VGND VPWR _0710_/A _0710_/Y _0710_/B sky130_fd_sc_hd__nand2_1
X_0641_ VPWR VGND VGND VPWR _0641_/A _0641_/Y _0641_/B sky130_fd_sc_hd__nand2_1
X_0572_ VPWR VGND VGND VPWR _0572_/A _0572_/Y _0572_/B sky130_fd_sc_hd__nand2_1
X_0908_ VPWR VGND VGND VPWR _0908_/A _0908_/Y _0908_/B sky130_fd_sc_hd__nand2_1
X_0839_ VPWR VGND VGND VPWR _0839_/A _0839_/Y _0839_/B sky130_fd_sc_hd__nand2_1
XPHY_4 VPWR VGND VPWR VGND sky130_fd_sc_hd__decap_3
X_0624_ VGND VPWR VGND VPWR _0624_/B1 _0624_/A1 _0624_/Y _0624_/A2 sky130_fd_sc_hd__o21ai_0
X_0486_ VPWR VGND VGND VPWR _0486_/A_N _0486_/B _0486_/Y sky130_fd_sc_hd__nand2b_1
X_0555_ VPWR VGND VPWR VGND _0555_/B2 _0555_/B1 _0555_/Y _0555_/A1 _0555_/A2 sky130_fd_sc_hd__a22oi_1
X_0607_ VPWR VGND VGND VPWR _0607_/A _0607_/Y _0607_/B sky130_fd_sc_hd__nand2_1
X_0538_ VPWR VGND VGND VPWR _0538_/A _0538_/Y _0538_/B sky130_fd_sc_hd__nand2_1
X_0469_ VPWR VGND _0469_/A1 _0469_/A2 _0469_/A3 _0469_/Y _0469_/B1 VPWR VGND sky130_fd_sc_hd__o31ai_1
X_0941_ VGND VPWR VPWR VGND _0941_/CLK _0941_/D _0941_/RESET_B _0941_/Q sky130_fd_sc_hd__dfrtp_1
X_0872_ VPWR VGND VGND VPWR _0872_/A _0872_/Y _0872_/B sky130_fd_sc_hd__nand2_1
X_0924_ VGND VPWR VPWR VGND _0924_/CLK _0924_/D _0924_/RESET_B _0924_/Q sky130_fd_sc_hd__dfrtp_1
X_0855_ VGND VPWR VGND VPWR _0855_/B1 _0855_/A1 _0855_/Y _0855_/A2 sky130_fd_sc_hd__o21ai_0
X_0786_ VGND VPWR VGND VPWR _0786_/B1 _0786_/A1 _0786_/Y _0786_/A2 sky130_fd_sc_hd__o21ai_0
X_0571_ VPWR VGND VPWR VGND _0571_/B _0571_/C _0571_/A _0571_/X sky130_fd_sc_hd__or3_1
X_0640_ VPWR VGND VGND VPWR _0640_/A _0640_/Y _0640_/B sky130_fd_sc_hd__nand2_1
X_0907_ VPWR VGND VGND VPWR _0907_/A _0907_/B _0907_/Y sky130_fd_sc_hd__nor2_1
X_0769_ VPWR VGND VGND VPWR _0769_/A _0769_/Y _0769_/B sky130_fd_sc_hd__nand2_1
X_0838_ VPWR VGND VGND VPWR _0838_/A _0838_/Y _0838_/B sky130_fd_sc_hd__nand2_1
XPHY_5 VPWR VGND VPWR VGND sky130_fd_sc_hd__decap_3
X_0623_ VPWR VGND VGND VPWR _0623_/A _0623_/Y _0623_/B sky130_fd_sc_hd__nand2_1
X_0554_ VGND VPWR VPWR VGND _0554_/C2 _0554_/C1 _0554_/B1 _0554_/A2 _0554_/A1 _0554_/Y
+ _0554_/B2 sky130_fd_sc_hd__a222oi_1
X_0485_ VPWR VGND VGND VPWR _0485_/A_N _0485_/B _0485_/Y sky130_fd_sc_hd__nand2b_1
X_1037_ _1037_/LO _1037_/HI VPWR VGND VGND VPWR sky130_fd_sc_hd__conb_1
X_0606_ VPWR VGND VGND VPWR _0606_/B2 _0606_/A2 _0606_/A1 _0606_/B1 _0606_/X sky130_fd_sc_hd__o22a_1
X_0537_ VPWR VGND VGND VPWR _0537_/A _0537_/Y _0537_/B sky130_fd_sc_hd__nand2_1
X_0468_ VPWR VGND VGND VPWR _0468_/C _0468_/B _0468_/A _0468_/Y sky130_fd_sc_hd__nor3_1
Xclkbuf_3_2__f_clk VGND VPWR VGND VPWR clkbuf_3_2__f_clk/A clkbuf_3_2__f_clk/X sky130_fd_sc_hd__clkbuf_16
X_0940_ VGND VPWR VPWR VGND _0940_/CLK _0940_/D _0940_/RESET_B _0940_/Q sky130_fd_sc_hd__dfrtp_1
X_0871_ VPWR VGND VGND VPWR _0871_/A _0871_/Y _0871_/B sky130_fd_sc_hd__nand2_1
X_0923_ VGND VPWR VPWR VGND _0923_/CLK _0923_/D _0923_/RESET_B _0923_/Q sky130_fd_sc_hd__dfrtp_1
X_0854_ VPWR VGND VGND VPWR _0854_/A _0854_/Y _0854_/B sky130_fd_sc_hd__nand2_1
X_0785_ VPWR VGND VGND VPWR _0785_/A _0785_/Y _0785_/B sky130_fd_sc_hd__nand2_1
X_0570_ VPWR VGND VPWR VGND _0570_/A _0570_/C _0570_/D _0570_/Y _0570_/B sky130_fd_sc_hd__nand4_1
X_0906_ VPWR VGND VGND VPWR _0906_/A _0906_/Y _0906_/B sky130_fd_sc_hd__nand2_1
X_0837_ VGND VPWR VGND VPWR _0837_/B1 _0837_/A1 _0837_/Y _0837_/A2 sky130_fd_sc_hd__o21ai_0
X_0768_ VPWR VGND VGND VPWR _0768_/A _0768_/Y _0768_/B sky130_fd_sc_hd__nand2_1
X_0699_ VPWR VGND VGND VPWR _0699_/A _0699_/Y _0699_/B sky130_fd_sc_hd__nand2_1
XPHY_6 VPWR VGND VPWR VGND sky130_fd_sc_hd__decap_3
X_0622_ VPWR VGND VGND VPWR _0622_/A _0622_/Y _0622_/B sky130_fd_sc_hd__nand2_1
X_0484_ VPWR VGND VGND VPWR _0484_/C _0484_/B _0484_/A _0484_/Y sky130_fd_sc_hd__nor3_1
X_0553_ VPWR VGND VGND VPWR _0553_/A _0553_/Y _0553_/B sky130_fd_sc_hd__nand2_1
X_1036_ _1036_/LO _1036_/HI VPWR VGND VGND VPWR sky130_fd_sc_hd__conb_1
X_0467_ VGND VPWR VGND VPWR _0467_/B1 _0467_/A1 _0467_/Y _0467_/A2 sky130_fd_sc_hd__o21ai_0
X_0605_ VPWR VGND VGND VPWR _0605_/Y _0605_/D _0605_/C _0605_/B _0605_/A sky130_fd_sc_hd__nor4_1
X_0536_ VPWR VGND VGND VPWR _0536_/A1 _0536_/A2 _0536_/B1 _0536_/X sky130_fd_sc_hd__o21a_1
X_1019_ _1019_/Q _1019_/CLK _1019_/D VPWR VGND VPWR VGND sky130_fd_sc_hd__dfxtp_1
X_0519_ VGND VPWR VPWR VGND _0519_/C2 _0519_/C1 _0519_/B1 _0519_/A2 _0519_/A1 _0519_/Y
+ _0519_/B2 sky130_fd_sc_hd__a222oi_1
X_0870_ VPWR VGND VGND VPWR _0870_/A _0870_/Y _0870_/B sky130_fd_sc_hd__nand2_1
X_0999_ VGND VPWR VPWR VGND _0999_/CLK _0999_/D _0999_/RESET_B _0999_/Q sky130_fd_sc_hd__dfrtp_1
X_0922_ VGND VPWR VPWR VGND _0922_/CLK _0922_/D _0922_/RESET_B _0922_/Q sky130_fd_sc_hd__dfrtp_1
X_0853_ VPWR VGND VGND VPWR _0853_/A _0853_/Y _0853_/B sky130_fd_sc_hd__nand2_1
X_0784_ VPWR VGND VGND VPWR _0784_/A _0784_/Y _0784_/B sky130_fd_sc_hd__nand2_1
X_0905_ VPWR VGND VGND VPWR _0905_/A _0905_/Y _0905_/B sky130_fd_sc_hd__nand2_1
X_0767_ VPWR VGND VGND VPWR _0767_/A _0767_/Y _0767_/B sky130_fd_sc_hd__nand2_1
X_0836_ VPWR VGND VGND VPWR _0836_/A _0836_/Y _0836_/B sky130_fd_sc_hd__nand2_1
X_0698_ VPWR VGND VGND VPWR _0698_/A _0698_/Y _0698_/B sky130_fd_sc_hd__nand2_1
XPHY_7 VPWR VGND VPWR VGND sky130_fd_sc_hd__decap_3
X_0621_ VGND VPWR VGND VPWR _0621_/B1 _0621_/A1 _0621_/Y _0621_/A2 sky130_fd_sc_hd__o21ai_0
X_0483_ VPWR VGND VGND VPWR _0483_/A _0483_/Y _0483_/B sky130_fd_sc_hd__nand2_1
X_0552_ VPWR VGND VGND VPWR _0552_/A1 _0552_/A2 _0552_/B1 _0552_/X sky130_fd_sc_hd__o21a_1
X_1035_ _1035_/LO _1035_/HI VPWR VGND VGND VPWR sky130_fd_sc_hd__conb_1
X_0819_ VGND VPWR VGND VPWR _0819_/B1 _0819_/A1 _0819_/Y _0819_/A2 sky130_fd_sc_hd__o21ai_0
X_0604_ VPWR VGND VPWR VGND _0604_/A _0604_/C _0604_/D _0604_/Y _0604_/B sky130_fd_sc_hd__nand4_1
X_0466_ VGND VPWR VPWR VGND _0466_/B2 _0466_/Y _0466_/B1 _0466_/A1 _0466_/A2 _0466_/A3
+ sky130_fd_sc_hd__a32oi_1
X_0535_ VPWR VGND VGND VPWR _0535_/A _0535_/B _0535_/Y _0535_/C sky130_fd_sc_hd__nand3_1
X_1018_ _1018_/Q _1018_/CLK _1018_/D VPWR VGND VPWR VGND sky130_fd_sc_hd__dfxtp_1
X_0518_ VGND VPWR VPWR VGND _0518_/C2 _0518_/C1 _0518_/B1 _0518_/A2 _0518_/A1 _0518_/Y
+ _0518_/B2 sky130_fd_sc_hd__a222oi_1
X_0998_ VGND VPWR VPWR VGND _0998_/CLK _0998_/D _0998_/RESET_B _0998_/Q sky130_fd_sc_hd__dfrtp_1
X_0921_ VGND VPWR VPWR VGND _0921_/CLK _0921_/D _0921_/RESET_B _0921_/Q sky130_fd_sc_hd__dfrtp_1
X_0852_ VPWR VGND VGND VPWR _0852_/A _0852_/Y _0852_/B sky130_fd_sc_hd__nand2_1
X_0783_ VPWR VGND VGND VPWR _0783_/A _0783_/Y _0783_/B sky130_fd_sc_hd__nand2_1
X_0904_ VGND VPWR VPWR VGND _0904_/X _0904_/A1 _0904_/S _0904_/A0 sky130_fd_sc_hd__mux2_1
X_0766_ VPWR VGND VGND VPWR _0766_/A _0766_/Y _0766_/B sky130_fd_sc_hd__nand2_1
X_0835_ VPWR VGND VGND VPWR _0835_/A _0835_/Y _0835_/B sky130_fd_sc_hd__nand2_1
X_0697_ VPWR VGND VGND VPWR _0697_/A _0697_/Y _0697_/B sky130_fd_sc_hd__nand2_1
XPHY_8 VPWR VGND VPWR VGND sky130_fd_sc_hd__decap_3
X_0620_ VPWR VGND VGND VPWR _0620_/A _0620_/Y _0620_/B sky130_fd_sc_hd__nand2_1
X_0551_ VPWR VGND VPWR VGND _0551_/A _0551_/C _0551_/D _0551_/Y _0551_/B sky130_fd_sc_hd__nand4_1
X_0482_ VPWR VGND VGND VPWR _0482_/Y _0482_/D _0482_/C _0482_/B _0482_/A sky130_fd_sc_hd__nor4_1
X_1034_ _1034_/LO _1034_/HI VPWR VGND VGND VPWR sky130_fd_sc_hd__conb_1
X_0818_ VPWR VGND VGND VPWR _0818_/A _0818_/Y _0818_/B sky130_fd_sc_hd__nand2_1
X_0749_ VPWR VGND VGND VPWR _0749_/A _0749_/Y _0749_/B sky130_fd_sc_hd__nand2_1
X_0534_ VGND VPWR VPWR VGND _0534_/C2 _0534_/C1 _0534_/B1 _0534_/A2 _0534_/A1 _0534_/Y
+ _0534_/B2 sky130_fd_sc_hd__a222oi_1
X_0603_ VPWR VGND VGND VPWR _0603_/Y _0603_/D _0603_/C _0603_/B _0603_/A sky130_fd_sc_hd__nor4_1
X_0465_ VPWR VGND VGND VPWR _0465_/A _0465_/SLEEP _0465_/X sky130_fd_sc_hd__lpflow_isobufsrc_1
X_1017_ _1017_/Q _1017_/CLK _1017_/D VPWR VGND VPWR VGND sky130_fd_sc_hd__dfxtp_1
X_0517_ VPWR VGND VGND VPWR _0517_/A _0517_/Y _0517_/B sky130_fd_sc_hd__nand2_1
X_0997_ VGND VPWR VPWR VGND _0997_/CLK _0997_/D _0997_/RESET_B _0997_/Q sky130_fd_sc_hd__dfrtp_1
X_0920_ VGND VPWR VPWR VGND _0920_/CLK _0920_/D _0920_/RESET_B _0920_/Q sky130_fd_sc_hd__dfrtp_1
X_0851_ VPWR VGND VGND VPWR _0851_/A _0851_/Y _0851_/B sky130_fd_sc_hd__nand2_1
X_0782_ VPWR VGND VGND VPWR _0782_/A _0782_/Y _0782_/B sky130_fd_sc_hd__nand2_1
X_0903_ VPWR VGND VPWR VGND _0903_/A2 _0903_/A1 _0903_/B1 _0903_/Y sky130_fd_sc_hd__a21oi_1
X_0834_ VPWR VGND VGND VPWR _0834_/A _0834_/Y _0834_/B sky130_fd_sc_hd__nand2_1
X_0765_ VPWR VGND VGND VPWR _0765_/A _0765_/Y _0765_/B sky130_fd_sc_hd__nand2_1
X_0696_ VPWR VGND VGND VPWR _0696_/A _0696_/Y _0696_/B sky130_fd_sc_hd__nand2_1
XPHY_9 VPWR VGND VPWR VGND sky130_fd_sc_hd__decap_3
X_0550_ VGND VPWR VPWR VGND _0550_/C2 _0550_/C1 _0550_/B1 _0550_/A2 _0550_/A1 _0550_/Y
+ _0550_/B2 sky130_fd_sc_hd__a222oi_1
X_0481_ VPWR VGND VGND VPWR _0481_/A _0481_/SLEEP _0481_/X sky130_fd_sc_hd__lpflow_isobufsrc_1
X_1033_ _1033_/LO _1033_/HI VPWR VGND VGND VPWR sky130_fd_sc_hd__conb_1
X_0817_ VPWR VGND VGND VPWR _0817_/A _0817_/Y _0817_/B sky130_fd_sc_hd__nand2_1
X_0679_ VPWR VGND VGND VPWR _0679_/A _0679_/Y _0679_/B sky130_fd_sc_hd__nand2_1
X_0748_ VPWR VGND VGND VPWR _0748_/A _0748_/Y _0748_/B sky130_fd_sc_hd__nand2_1
X_0464_ VPWR VGND VGND VPWR _0464_/A_N _0464_/B _0464_/Y sky130_fd_sc_hd__nand2b_1
X_0533_ VGND VPWR VPWR VGND _0533_/C2 _0533_/C1 _0533_/B1 _0533_/A2 _0533_/A1 _0533_/Y
+ _0533_/B2 sky130_fd_sc_hd__a222oi_1
X_0602_ VPWR VGND VPWR VGND _0602_/B _0602_/C _0602_/A _0602_/X _0602_/D_N sky130_fd_sc_hd__or4b_1
X_1016_ _1016_/Q _1016_/CLK _1016_/D VPWR VGND VPWR VGND sky130_fd_sc_hd__dfxtp_1
X_0516_ VPWR VGND VPWR VGND _0516_/B2 _0516_/B1 _0516_/Y _0516_/A1 _0516_/A2 sky130_fd_sc_hd__a22oi_1
X_0996_ VGND VPWR VPWR VGND _0996_/CLK _0996_/D _0996_/RESET_B _0996_/Q sky130_fd_sc_hd__dfrtp_1
X_0850_ VPWR VGND VGND VPWR _0850_/A _0850_/Y _0850_/B sky130_fd_sc_hd__nand2_1
X_0781_ VPWR VGND VGND VPWR _0781_/A _0781_/Y _0781_/B sky130_fd_sc_hd__nand2_1
X_0979_ VGND VPWR VPWR VGND _0979_/CLK _0979_/D _0979_/RESET_B _0979_/Q sky130_fd_sc_hd__dfrtp_1
X_0902_ VGND VPWR VPWR VGND _0902_/A1 _0902_/A2 _0902_/B1_N _0902_/Y sky130_fd_sc_hd__a21boi_0
X_0833_ VPWR VGND VGND VPWR _0833_/A _0833_/Y _0833_/B sky130_fd_sc_hd__nand2_1
X_0764_ VPWR VGND VGND VPWR _0764_/A _0764_/Y _0764_/B sky130_fd_sc_hd__nand2_1
X_0695_ VPWR VGND VGND VPWR _0695_/A _0695_/Y _0695_/B sky130_fd_sc_hd__nand2_1
X_0480_ VPWR VGND VGND VPWR _0480_/A1 _0480_/A2 _0480_/B1 _0480_/Y _0480_/B2 _0480_/A3
+ sky130_fd_sc_hd__o32ai_1
X_1032_ _1032_/LO _1032_/HI VPWR VGND VGND VPWR sky130_fd_sc_hd__conb_1
X_0816_ VPWR VGND VGND VPWR _0816_/A _0816_/Y _0816_/B sky130_fd_sc_hd__nand2_1
X_0747_ VGND VPWR VGND VPWR _0747_/B1 _0747_/A1 _0747_/Y _0747_/A2 sky130_fd_sc_hd__o21ai_0
X_0678_ VGND VPWR VGND VPWR _0678_/B1 _0678_/A1 _0678_/Y _0678_/A2 sky130_fd_sc_hd__o21ai_0
X_0601_ VPWR VGND VPWR VGND _0601_/B _0601_/D _0601_/C _0601_/A _0601_/X sky130_fd_sc_hd__or4_1
X_0463_ VPWR VGND VGND VPWR _0463_/A _0463_/Y _0463_/B sky130_fd_sc_hd__nand2_1
X_0532_ VPWR VGND VGND VPWR _0532_/A _0532_/Y _0532_/B sky130_fd_sc_hd__nand2_1
X_1015_ VGND VPWR VPWR VGND _1015_/CLK _1015_/D _1015_/RESET_B _1015_/Q sky130_fd_sc_hd__dfrtp_1
X_0515_ VGND VPWR VPWR VGND _0515_/C2 _0515_/C1 _0515_/B1 _0515_/A2 _0515_/A1 _0515_/Y
+ _0515_/B2 sky130_fd_sc_hd__a222oi_1
X_0995_ VGND VPWR VPWR VGND _0995_/CLK _0995_/D _0995_/RESET_B _0995_/Q sky130_fd_sc_hd__dfrtp_1
X_0780_ VPWR VGND VGND VPWR _0780_/A _0780_/Y _0780_/B sky130_fd_sc_hd__nand2_1
X_0978_ VGND VPWR VPWR VGND _0978_/CLK _0978_/D _0978_/RESET_B _0978_/Q sky130_fd_sc_hd__dfrtp_1
X_0901_ VPWR VGND VGND VPWR _0901_/A _0901_/Y _0901_/B sky130_fd_sc_hd__nand2_1
X_0832_ VPWR VGND VGND VPWR _0832_/A _0832_/Y _0832_/B sky130_fd_sc_hd__nand2_1
X_0763_ VPWR VGND VGND VPWR _0763_/A _0763_/Y _0763_/B sky130_fd_sc_hd__nand2_1
X_0694_ VPWR VGND VGND VPWR _0694_/A _0694_/Y _0694_/B sky130_fd_sc_hd__nand2_1
X_1031_ _1031_/LO _1031_/HI VPWR VGND VGND VPWR sky130_fd_sc_hd__conb_1
X_0815_ VPWR VGND VGND VPWR _0815_/A _0815_/Y _0815_/B sky130_fd_sc_hd__nand2_1
X_0746_ VPWR VGND VGND VPWR _0746_/A _0746_/Y _0746_/B sky130_fd_sc_hd__nand2_1
X_0677_ VPWR VGND VGND VPWR _0677_/A _0677_/Y _0677_/B sky130_fd_sc_hd__nand2_1
X_0600_ VPWR VGND VGND VPWR _0600_/Y _0600_/C _0600_/B _0600_/D _0600_/A_N sky130_fd_sc_hd__nand4b_1
X_0531_ VPWR VGND VPWR VGND _0531_/B2 _0531_/B1 _0531_/Y _0531_/A1 _0531_/A2 sky130_fd_sc_hd__a22oi_1
X_0462_ VPWR VGND VGND VPWR _0462_/C _0462_/B _0462_/A _0462_/Y sky130_fd_sc_hd__nor3_1
X_1014_ VGND VPWR VPWR VGND _1014_/CLK _1014_/D _1014_/RESET_B _1014_/Q sky130_fd_sc_hd__dfrtp_1
X_0729_ VGND VPWR VGND VPWR _0729_/B1 _0729_/A1 _0729_/Y _0729_/A2 sky130_fd_sc_hd__o21ai_0
X_0514_ VPWR VGND VGND VPWR _0514_/A _0514_/Y _0514_/B sky130_fd_sc_hd__nand2_1
X_0994_ VGND VPWR VPWR VGND _0994_/CLK _0994_/D _0994_/RESET_B _0994_/Q sky130_fd_sc_hd__dfrtp_1
X_0977_ VGND VPWR VPWR VGND _0977_/CLK _0977_/D _0977_/RESET_B _0977_/Q sky130_fd_sc_hd__dfrtp_1
Xclkbuf_3_3__f_clk VGND VPWR VGND VPWR clkbuf_3_3__f_clk/A clkbuf_3_3__f_clk/X sky130_fd_sc_hd__clkbuf_16
X_0900_ VPWR VGND VGND VPWR _0900_/A _0900_/B _0900_/Y sky130_fd_sc_hd__nor2_1
X_0831_ VGND VPWR VGND VPWR _0831_/B1 _0831_/A1 _0831_/Y _0831_/A2 sky130_fd_sc_hd__o21ai_0
X_0762_ VGND VPWR VGND VPWR _0762_/B1 _0762_/A1 _0762_/Y _0762_/A2 sky130_fd_sc_hd__o21ai_0
X_0693_ VPWR VGND VGND VPWR _0693_/A _0693_/Y _0693_/B sky130_fd_sc_hd__nand2_1
X_1030_ _1030_/LO _1030_/HI VPWR VGND VGND VPWR sky130_fd_sc_hd__conb_1
X_0814_ VPWR VGND VGND VPWR _0814_/A _0814_/Y _0814_/B sky130_fd_sc_hd__nand2_1
X_0676_ VPWR VGND VGND VPWR _0676_/A _0676_/Y _0676_/B sky130_fd_sc_hd__nand2_1
X_0745_ VPWR VGND VGND VPWR _0745_/A _0745_/Y _0745_/B sky130_fd_sc_hd__nand2_1
X_0530_ VGND VPWR VPWR VGND _0530_/C2 _0530_/C1 _0530_/B1 _0530_/A2 _0530_/A1 _0530_/Y
+ _0530_/B2 sky130_fd_sc_hd__a222oi_1
X_0461_ VPWR VGND VGND VPWR _0461_/C _0461_/B _0461_/A _0461_/Y sky130_fd_sc_hd__nor3_1
X_1013_ VGND VPWR VPWR VGND _1013_/CLK _1013_/D _1013_/RESET_B _1013_/Q sky130_fd_sc_hd__dfrtp_1
X_0728_ VPWR VGND VGND VPWR _0728_/A _0728_/Y _0728_/B sky130_fd_sc_hd__nand2_1
X_0659_ VPWR VGND VGND VPWR _0659_/A _0659_/Y _0659_/B sky130_fd_sc_hd__nand2_1
X_0513_ VPWR VGND VGND VPWR _0513_/A1 _0513_/A2 _0513_/B1 _0513_/X sky130_fd_sc_hd__o21a_1
X_0993_ VGND VPWR VPWR VGND _0993_/CLK _0993_/D _0993_/RESET_B _0993_/Q sky130_fd_sc_hd__dfrtp_1
X_0976_ VGND VPWR VPWR VGND _0976_/CLK _0976_/D _0976_/RESET_B _0976_/Q sky130_fd_sc_hd__dfrtp_1
X_0830_ VPWR VGND VGND VPWR _0830_/A _0830_/Y _0830_/B sky130_fd_sc_hd__nand2_1
X_0761_ VPWR VGND VGND VPWR _0761_/A _0761_/Y _0761_/B sky130_fd_sc_hd__nand2_1
X_0692_ VPWR VGND VGND VPWR _0692_/A _0692_/Y _0692_/B sky130_fd_sc_hd__nand2_1
X_0959_ VGND VPWR VPWR VGND _0959_/CLK _0959_/D _0959_/RESET_B _0959_/Q sky130_fd_sc_hd__dfrtp_1
X_0813_ VGND VPWR VGND VPWR _0813_/B1 _0813_/A1 _0813_/Y _0813_/A2 sky130_fd_sc_hd__o21ai_0
X_0744_ VGND VPWR VGND VPWR _0744_/B1 _0744_/A1 _0744_/Y _0744_/A2 sky130_fd_sc_hd__o21ai_0
X_0675_ VGND VPWR VGND VPWR _0675_/B1 _0675_/A1 _0675_/Y _0675_/A2 sky130_fd_sc_hd__o21ai_0
X_0460_ VPWR VGND VGND VPWR _0460_/A _0460_/B _0460_/Y sky130_fd_sc_hd__nor2_1
X_1012_ VGND VPWR VPWR VGND _1012_/CLK _1012_/D _1012_/RESET_B _1012_/Q sky130_fd_sc_hd__dfrtp_1
X_0727_ VPWR VGND VGND VPWR _0727_/A _0727_/Y _0727_/B sky130_fd_sc_hd__nand2_1
X_0658_ VPWR VGND VGND VPWR _0658_/A _0658_/Y _0658_/B sky130_fd_sc_hd__nand2_1
X_0589_ VPWR VGND VPWR VGND _0589_/A _0589_/C _0589_/D _0589_/Y _0589_/B sky130_fd_sc_hd__nand4_1
X_0512_ VPWR VGND VPWR VGND _0512_/A _0512_/C _0512_/D _0512_/Y _0512_/B sky130_fd_sc_hd__nand4_1
X_0992_ VGND VPWR VPWR VGND _0992_/CLK _0992_/D _0992_/RESET_B _0992_/Q sky130_fd_sc_hd__dfrtp_1
X_0975_ VGND VPWR VPWR VGND _0975_/CLK _0975_/D _0975_/RESET_B _0975_/Q sky130_fd_sc_hd__dfrtp_1
XPHY_70 VPWR VGND VPWR VGND sky130_fd_sc_hd__decap_3
X_0760_ VPWR VGND VGND VPWR _0760_/A _0760_/Y _0760_/B sky130_fd_sc_hd__nand2_1
X_0691_ VPWR VGND VGND VPWR _0691_/A _0691_/Y _0691_/B sky130_fd_sc_hd__nand2_1
X_0889_ VPWR VGND VGND VPWR _0889_/A _0889_/Y _0889_/B sky130_fd_sc_hd__nand2_1
X_0958_ VGND VPWR VPWR VGND _0958_/CLK _0958_/D _0958_/RESET_B _0958_/Q sky130_fd_sc_hd__dfrtp_1
X_0743_ VPWR VGND VGND VPWR _0743_/A _0743_/Y _0743_/B sky130_fd_sc_hd__nand2_1
X_0812_ VPWR VGND VGND VPWR _0812_/A _0812_/Y _0812_/B sky130_fd_sc_hd__nand2_1
X_0674_ VPWR VGND VGND VPWR _0674_/A _0674_/Y _0674_/B sky130_fd_sc_hd__nand2_1
X_1011_ VGND VPWR VPWR VGND _1011_/CLK _1011_/D _1011_/RESET_B _1011_/Q sky130_fd_sc_hd__dfrtp_1
X_0726_ VGND VPWR VGND VPWR _0726_/B1 _0726_/A1 _0726_/Y _0726_/A2 sky130_fd_sc_hd__o21ai_0
X_0588_ VPWR VGND VGND VPWR _0588_/C _0588_/B _0588_/A _0588_/Y sky130_fd_sc_hd__nor3_1
X_0657_ VGND VPWR VGND VPWR _0657_/B1 _0657_/A1 _0657_/Y _0657_/A2 sky130_fd_sc_hd__o21ai_0
X_0511_ VGND VPWR VPWR VGND _0511_/C2 _0511_/C1 _0511_/B1 _0511_/A2 _0511_/A1 _0511_/Y
+ _0511_/B2 sky130_fd_sc_hd__a222oi_1
X_0709_ VPWR VGND VGND VPWR _0709_/A _0709_/Y _0709_/B sky130_fd_sc_hd__nand2_1
X_0991_ VGND VPWR VPWR VGND _0991_/CLK _0991_/D _0991_/RESET_B _0991_/Q sky130_fd_sc_hd__dfrtp_1
X_0974_ VGND VPWR VPWR VGND _0974_/CLK _0974_/D _0974_/RESET_B _0974_/Q sky130_fd_sc_hd__dfrtp_1
XPHY_71 VPWR VGND VPWR VGND sky130_fd_sc_hd__decap_3
XPHY_60 VPWR VGND VPWR VGND sky130_fd_sc_hd__decap_3
X_0690_ VPWR VGND VGND VPWR _0690_/A _0690_/Y _0690_/B sky130_fd_sc_hd__nand2_1
X_0957_ VGND VPWR VPWR VGND _0957_/CLK _0957_/D _0957_/RESET_B _0957_/Q sky130_fd_sc_hd__dfrtp_1
X_0888_ VPWR VGND VGND VPWR _0888_/A _0888_/Y _0888_/B sky130_fd_sc_hd__nand2_1
X_0742_ VPWR VGND VGND VPWR _0742_/A _0742_/Y _0742_/B sky130_fd_sc_hd__nand2_1
X_0673_ VPWR VGND VGND VPWR _0673_/A _0673_/Y _0673_/B sky130_fd_sc_hd__nand2_1
X_0811_ VPWR VGND VGND VPWR _0811_/A _0811_/Y _0811_/B sky130_fd_sc_hd__nand2_1
X_1010_ VGND VPWR VPWR VGND _1010_/CLK _1010_/D _1010_/RESET_B _1010_/Q sky130_fd_sc_hd__dfrtp_1
X_0725_ VPWR VGND VGND VPWR _0725_/A _0725_/Y _0725_/B sky130_fd_sc_hd__nand2_1
X_0656_ VPWR VGND VGND VPWR _0656_/A _0656_/Y _0656_/B sky130_fd_sc_hd__nand2_1
X_0587_ VPWR VGND VPWR VGND _0587_/A _0587_/C _0587_/D _0587_/Y _0587_/B sky130_fd_sc_hd__nand4_1
X_0510_ VGND VPWR VPWR VGND _0510_/C2 _0510_/C1 _0510_/B1 _0510_/A2 _0510_/A1 _0510_/Y
+ _0510_/B2 sky130_fd_sc_hd__a222oi_1
X_0708_ VPWR VGND VGND VPWR _0708_/A _0708_/Y _0708_/B sky130_fd_sc_hd__nand2_1
X_0639_ VGND VPWR VGND VPWR _0639_/B1 _0639_/A1 _0639_/Y _0639_/A2 sky130_fd_sc_hd__o21ai_0
X_0990_ VGND VPWR VPWR VGND _0990_/CLK _0990_/D _0990_/RESET_B _0990_/Q sky130_fd_sc_hd__dfrtp_1
X_0973_ VGND VPWR VPWR VGND _0973_/CLK _0973_/D _0973_/RESET_B _0973_/Q sky130_fd_sc_hd__dfrtp_1
XPHY_72 VPWR VGND VPWR VGND sky130_fd_sc_hd__decap_3
XPHY_61 VPWR VGND VPWR VGND sky130_fd_sc_hd__decap_3
XPHY_50 VPWR VGND VPWR VGND sky130_fd_sc_hd__decap_3
X_0956_ VGND VPWR VPWR VGND _0956_/CLK _0956_/D _0956_/RESET_B _0956_/Q sky130_fd_sc_hd__dfrtp_1
X_0887_ VPWR VGND VGND VPWR _0887_/A _0887_/Y _0887_/B sky130_fd_sc_hd__nand2_1
X_0810_ VPWR VGND VGND VPWR _0810_/A _0810_/Y _0810_/B sky130_fd_sc_hd__nand2_1
X_0741_ VPWR VGND VGND VPWR _0741_/A _0741_/Y _0741_/B sky130_fd_sc_hd__nand2_1
X_0672_ VGND VPWR VGND VPWR _0672_/B1 _0672_/A1 _0672_/Y _0672_/A2 sky130_fd_sc_hd__o21ai_0
X_0939_ VGND VPWR VPWR VGND _0939_/CLK _0939_/D _0939_/RESET_B _0939_/Q sky130_fd_sc_hd__dfrtp_1
X_0724_ VPWR VGND VGND VPWR _0724_/A _0724_/Y _0724_/B sky130_fd_sc_hd__nand2_1
X_0586_ VPWR VGND VGND VPWR _0586_/A _0586_/B _0586_/Y _0586_/C sky130_fd_sc_hd__nand3_1
X_0655_ VPWR VGND VGND VPWR _0655_/A _0655_/Y _0655_/B sky130_fd_sc_hd__nand2_1
X_0707_ VPWR VGND VGND VPWR _0707_/A _0707_/Y _0707_/B sky130_fd_sc_hd__nand2_1
X_0569_ VGND VPWR VGND VPWR _0569_/A _0569_/Y _0569_/B _0569_/D_N _0569_/C_N sky130_fd_sc_hd__nor4bb_1
X_0638_ VPWR VGND VGND VPWR _0638_/A _0638_/Y _0638_/B sky130_fd_sc_hd__nand2_1
X_0972_ VGND VPWR VPWR VGND _0972_/CLK _0972_/D _0972_/RESET_B _0972_/Q sky130_fd_sc_hd__dfrtp_1
XPHY_73 VPWR VGND VPWR VGND sky130_fd_sc_hd__decap_3
XPHY_62 VPWR VGND VPWR VGND sky130_fd_sc_hd__decap_3
XPHY_51 VPWR VGND VPWR VGND sky130_fd_sc_hd__decap_3
XPHY_40 VPWR VGND VPWR VGND sky130_fd_sc_hd__decap_3
X_0955_ VGND VPWR VPWR VGND _0955_/CLK _0955_/D _0955_/RESET_B _0955_/Q sky130_fd_sc_hd__dfrtp_1
X_0886_ VPWR VGND VGND VPWR _0886_/A _0886_/Y _0886_/B sky130_fd_sc_hd__nand2_1
X_0740_ VPWR VGND VGND VPWR _0740_/A _0740_/Y _0740_/B sky130_fd_sc_hd__nand2_1
X_0671_ VPWR VGND VGND VPWR _0671_/A _0671_/Y _0671_/B sky130_fd_sc_hd__nand2_1
X_0869_ VPWR VGND VGND VPWR _0869_/A _0869_/Y _0869_/B sky130_fd_sc_hd__nand2_1
X_0938_ VGND VPWR VPWR VGND _0938_/CLK _0938_/D _0938_/RESET_B _0938_/Q sky130_fd_sc_hd__dfrtp_1
X_0723_ VGND VPWR VGND VPWR _0723_/B1 _0723_/A1 _0723_/Y _0723_/A2 sky130_fd_sc_hd__o21ai_0
X_0585_ VPWR VGND VGND VPWR _0585_/Y _0585_/D _0585_/C _0585_/B _0585_/A sky130_fd_sc_hd__nor4_1
X_0654_ VGND VPWR VGND VPWR _0654_/B1 _0654_/A1 _0654_/Y _0654_/A2 sky130_fd_sc_hd__o21ai_0
X_0706_ VPWR VGND VGND VPWR _0706_/A _0706_/Y _0706_/B sky130_fd_sc_hd__nand2_1
X_0499_ VPWR VGND VGND VPWR _0499_/A _0499_/B _0499_/Y sky130_fd_sc_hd__nor2_1
X_0568_ VPWR VGND VGND VPWR _0568_/A _0568_/B _0568_/Y sky130_fd_sc_hd__nor2_1
X_0637_ VPWR VGND VGND VPWR _0637_/A _0637_/Y _0637_/B sky130_fd_sc_hd__nand2_1
X_0971_ VGND VPWR VPWR VGND _0971_/CLK _0971_/D _0971_/RESET_B _0971_/Q sky130_fd_sc_hd__dfrtp_1
XPHY_30 VPWR VGND VPWR VGND sky130_fd_sc_hd__decap_3
XPHY_74 VPWR VGND VPWR VGND sky130_fd_sc_hd__decap_3
XPHY_63 VPWR VGND VPWR VGND sky130_fd_sc_hd__decap_3
XPHY_52 VPWR VGND VPWR VGND sky130_fd_sc_hd__decap_3
XPHY_41 VPWR VGND VPWR VGND sky130_fd_sc_hd__decap_3
X_0954_ VGND VPWR VPWR VGND _0954_/CLK _0954_/D _0954_/RESET_B _0954_/Q sky130_fd_sc_hd__dfrtp_1
X_0885_ VGND VPWR VGND VPWR _0885_/B1 _0885_/A1 _0885_/Y _0885_/A2 sky130_fd_sc_hd__o21ai_0
X_0670_ VPWR VGND VGND VPWR _0670_/A _0670_/Y _0670_/B sky130_fd_sc_hd__nand2_1
X_0868_ VPWR VGND VGND VPWR _0868_/A _0868_/Y _0868_/B sky130_fd_sc_hd__nand2_1
X_0937_ VGND VPWR VPWR VGND _0937_/CLK _0937_/D _0937_/RESET_B _0937_/Q sky130_fd_sc_hd__dfrtp_1
X_0799_ VPWR VGND VGND VPWR _0799_/A _0799_/Y _0799_/B sky130_fd_sc_hd__nand2_1
Xclkbuf_3_4__f_clk VGND VPWR VGND VPWR clkbuf_3_4__f_clk/A clkbuf_3_4__f_clk/X sky130_fd_sc_hd__clkbuf_16
X_0722_ VPWR VGND VGND VPWR _0722_/A _0722_/Y _0722_/B sky130_fd_sc_hd__nand2_1
X_0653_ VPWR VGND VGND VPWR _0653_/A _0653_/Y _0653_/B sky130_fd_sc_hd__nand2_1
X_0584_ VPWR VGND VGND VPWR _0584_/Y _0584_/C _0584_/B _0584_/D _0584_/A_N sky130_fd_sc_hd__nand4b_1
X_0705_ VPWR VGND VGND VPWR _0705_/A _0705_/Y _0705_/B sky130_fd_sc_hd__nand2_1
X_0636_ VGND VPWR VGND VPWR _0636_/B1 _0636_/A1 _0636_/Y _0636_/A2 sky130_fd_sc_hd__o21ai_0
X_0498_ VPWR VGND VGND VPWR _0498_/A _0498_/B _0498_/Y sky130_fd_sc_hd__nor2_1
X_0567_ VPWR VGND VGND VPWR _0567_/A _0567_/Y _0567_/B sky130_fd_sc_hd__nand2_1
X_0619_ VPWR VGND VGND VPWR _0619_/A _0619_/Y _0619_/B sky130_fd_sc_hd__nand2_1
X_0970_ VGND VPWR VPWR VGND _0970_/CLK _0970_/D _0970_/RESET_B _0970_/Q sky130_fd_sc_hd__dfrtp_1
XPHY_64 VPWR VGND VPWR VGND sky130_fd_sc_hd__decap_3
XPHY_53 VPWR VGND VPWR VGND sky130_fd_sc_hd__decap_3
XPHY_20 VPWR VGND VPWR VGND sky130_fd_sc_hd__decap_3
XPHY_31 VPWR VGND VPWR VGND sky130_fd_sc_hd__decap_3
XPHY_42 VPWR VGND VPWR VGND sky130_fd_sc_hd__decap_3
XPHY_75 VPWR VGND VPWR VGND sky130_fd_sc_hd__decap_3
X_0953_ VGND VPWR VPWR VGND _0953_/CLK _0953_/D _0953_/RESET_B _0953_/Q sky130_fd_sc_hd__dfrtp_1
X_0884_ VPWR VGND VGND VPWR _0884_/A _0884_/Y _0884_/B sky130_fd_sc_hd__nand2_1
X_0936_ VGND VPWR VPWR VGND _0936_/CLK _0936_/D _0936_/RESET_B _0936_/Q sky130_fd_sc_hd__dfrtp_1
X_0867_ VGND VPWR VGND VPWR _0867_/B1 _0867_/A1 _0867_/Y _0867_/A2 sky130_fd_sc_hd__o21ai_0
X_0798_ VPWR VGND VGND VPWR _0798_/A _0798_/Y _0798_/B sky130_fd_sc_hd__nand2_1
X_0721_ VPWR VGND VGND VPWR _0721_/A _0721_/Y _0721_/B sky130_fd_sc_hd__nand2_1
X_0583_ VPWR VGND VGND VPWR _0583_/A _0583_/Y _0583_/B sky130_fd_sc_hd__nand2_1
X_0652_ VPWR VGND VGND VPWR _0652_/A _0652_/Y _0652_/B sky130_fd_sc_hd__nand2_1
X_0919_ VGND VPWR VPWR VGND _0919_/CLK _0919_/D _0919_/RESET_B _0919_/Q sky130_fd_sc_hd__dfrtp_1
X_0566_ VPWR VGND VGND VPWR _0566_/X _0566_/SLEEP _0566_/A sky130_fd_sc_hd__lpflow_inputiso1p_1
X_0704_ VPWR VGND VGND VPWR _0704_/A _0704_/Y _0704_/B sky130_fd_sc_hd__nand2_1
X_0635_ VPWR VGND VGND VPWR _0635_/A _0635_/Y _0635_/B sky130_fd_sc_hd__nand2_1
X_0497_ VPWR VGND VGND VPWR _0497_/C _0497_/B _0497_/A _0497_/Y sky130_fd_sc_hd__nor3_1
X_0618_ VGND VPWR VGND VPWR _0618_/B1 _0618_/A1 _0618_/Y _0618_/A2 sky130_fd_sc_hd__o21ai_0
X_0549_ VGND VPWR VPWR VGND _0549_/C2 _0549_/C1 _0549_/B1 _0549_/A2 _0549_/A1 _0549_/Y
+ _0549_/B2 sky130_fd_sc_hd__a222oi_1
XPHY_76 VPWR VGND VPWR VGND sky130_fd_sc_hd__decap_3
XPHY_65 VPWR VGND VPWR VGND sky130_fd_sc_hd__decap_3
XPHY_54 VPWR VGND VPWR VGND sky130_fd_sc_hd__decap_3
XPHY_10 VPWR VGND VPWR VGND sky130_fd_sc_hd__decap_3
XPHY_21 VPWR VGND VPWR VGND sky130_fd_sc_hd__decap_3
XPHY_32 VPWR VGND VPWR VGND sky130_fd_sc_hd__decap_3
XPHY_43 VPWR VGND VPWR VGND sky130_fd_sc_hd__decap_3
X_0952_ VGND VPWR VPWR VGND _0952_/CLK _0952_/D _0952_/RESET_B _0952_/Q sky130_fd_sc_hd__dfrtp_1
X_0883_ VPWR VGND VGND VPWR _0883_/A _0883_/Y _0883_/B sky130_fd_sc_hd__nand2_1
X_0866_ VPWR VGND VGND VPWR _0866_/A _0866_/Y _0866_/B sky130_fd_sc_hd__nand2_1
X_0935_ VGND VPWR VPWR VGND _0935_/CLK _0935_/D _0935_/RESET_B _0935_/Q sky130_fd_sc_hd__dfrtp_1
X_0797_ VPWR VGND VGND VPWR _0797_/A _0797_/Y _0797_/B sky130_fd_sc_hd__nand2_1
X_0720_ VPWR VGND VGND VPWR _0720_/A _0720_/Y _0720_/B sky130_fd_sc_hd__nand2_1
X_0582_ VPWR VGND VGND VPWR _0582_/D_N _0582_/C _0582_/Y _0582_/B _0582_/A sky130_fd_sc_hd__nor4b_1
X_0651_ VGND VPWR VGND VPWR _0651_/B1 _0651_/A1 _0651_/Y _0651_/A2 sky130_fd_sc_hd__o21ai_0
X_0918_ VPWR VGND VPWR VGND _0918_/Q _0918_/SET_B _0918_/D _0918_/CLK sky130_fd_sc_hd__dfstp_2
X_0849_ VGND VPWR VGND VPWR _0849_/B1 _0849_/A1 _0849_/Y _0849_/A2 sky130_fd_sc_hd__o21ai_0
X_0703_ VPWR VGND VGND VPWR _0703_/A _0703_/Y _0703_/B sky130_fd_sc_hd__nand2_1
X_0565_ VPWR VGND VGND VPWR _0565_/A _0565_/Y _0565_/B sky130_fd_sc_hd__nand2_1
X_0496_ VPWR VGND VGND VPWR _0496_/C _0496_/B _0496_/A _0496_/Y sky130_fd_sc_hd__nor3_1
X_0634_ VPWR VGND VGND VPWR _0634_/A _0634_/Y _0634_/B sky130_fd_sc_hd__nand2_1
X_0479_ VPWR VGND VGND VPWR _0479_/A _0479_/SLEEP _0479_/X sky130_fd_sc_hd__lpflow_isobufsrc_1
X_0617_ VPWR VGND VGND VPWR _0617_/A _0617_/Y _0617_/B sky130_fd_sc_hd__nand2_1
X_0548_ VPWR VGND VPWR VGND _0548_/B2 _0548_/B1 _0548_/Y _0548_/A1 _0548_/A2 sky130_fd_sc_hd__a22oi_1
XPHY_77 VPWR VGND VPWR VGND sky130_fd_sc_hd__decap_3
XPHY_66 VPWR VGND VPWR VGND sky130_fd_sc_hd__decap_3
XPHY_55 VPWR VGND VPWR VGND sky130_fd_sc_hd__decap_3
XPHY_11 VPWR VGND VPWR VGND sky130_fd_sc_hd__decap_3
XPHY_22 VPWR VGND VPWR VGND sky130_fd_sc_hd__decap_3
XPHY_33 VPWR VGND VPWR VGND sky130_fd_sc_hd__decap_3
XPHY_44 VPWR VGND VPWR VGND sky130_fd_sc_hd__decap_3
X_0951_ VGND VPWR VPWR VGND _0951_/CLK _0951_/D _0951_/RESET_B _0951_/Q sky130_fd_sc_hd__dfrtp_1
X_0882_ VPWR VGND VGND VPWR _0882_/A _0882_/Y _0882_/B sky130_fd_sc_hd__nand2_1
X_0934_ VGND VPWR VPWR VGND _0934_/CLK _0934_/D _0934_/RESET_B _0934_/Q sky130_fd_sc_hd__dfrtp_1
X_0865_ VPWR VGND VGND VPWR _0865_/A _0865_/Y _0865_/B sky130_fd_sc_hd__nand2_1
X_0796_ VPWR VGND VGND VPWR _0796_/A _0796_/Y _0796_/B sky130_fd_sc_hd__nand2_1
X_0650_ VPWR VGND VGND VPWR _0650_/A _0650_/Y _0650_/B sky130_fd_sc_hd__nand2_1
X_0581_ VGND VPWR _0581_/C _0581_/A_N _0581_/X _0581_/D _0581_/B VPWR VGND sky130_fd_sc_hd__and4b_1
X_0917_ VGND VPWR VPWR VGND _0917_/X _0917_/B _0917_/A sky130_fd_sc_hd__and2_0
X_0848_ VPWR VGND VGND VPWR _0848_/A _0848_/Y _0848_/B sky130_fd_sc_hd__nand2_1
X_0779_ VPWR VGND VGND VPWR _0779_/A _0779_/Y _0779_/B sky130_fd_sc_hd__nand2_1
X_0702_ VGND VPWR VGND VPWR _0702_/B1 _0702_/A1 _0702_/Y _0702_/A2 sky130_fd_sc_hd__o21ai_0
X_0633_ VGND VPWR VGND VPWR _0633_/B1 _0633_/A1 _0633_/Y _0633_/A2 sky130_fd_sc_hd__o21ai_0
X_0564_ VPWR VGND VGND VPWR _0564_/A _0564_/Y _0564_/B sky130_fd_sc_hd__nand2_1
X_0495_ VPWR VGND VGND VPWR _0495_/C _0495_/B _0495_/A _0495_/Y sky130_fd_sc_hd__nor3_1
X_0616_ VPWR VGND VGND VPWR _0616_/A _0616_/Y _0616_/B sky130_fd_sc_hd__nand2_1
X_0478_ VGND VPWR VGND VPWR _0478_/B1 _0478_/A1 _0478_/Y _0478_/A2 sky130_fd_sc_hd__o21ai_0
X_0547_ VPWR VGND VPWR VGND _0547_/B1 _0547_/A1 _0547_/A2 _0547_/X _0547_/B2 sky130_fd_sc_hd__a22o_1
XPHY_12 VPWR VGND VPWR VGND sky130_fd_sc_hd__decap_3
XPHY_67 VPWR VGND VPWR VGND sky130_fd_sc_hd__decap_3
XPHY_56 VPWR VGND VPWR VGND sky130_fd_sc_hd__decap_3
XPHY_23 VPWR VGND VPWR VGND sky130_fd_sc_hd__decap_3
XPHY_34 VPWR VGND VPWR VGND sky130_fd_sc_hd__decap_3
XPHY_45 VPWR VGND VPWR VGND sky130_fd_sc_hd__decap_3
X_0881_ VPWR VGND VGND VPWR _0881_/A _0881_/Y _0881_/B sky130_fd_sc_hd__nand2_1
X_0950_ VGND VPWR VPWR VGND _0950_/CLK _0950_/D _0950_/RESET_B _0950_/Q sky130_fd_sc_hd__dfrtp_1
X_0864_ VPWR VGND VGND VPWR _0864_/A _0864_/Y _0864_/B sky130_fd_sc_hd__nand2_1
X_0795_ VGND VPWR VGND VPWR _0795_/B1 _0795_/A1 _0795_/Y _0795_/A2 sky130_fd_sc_hd__o21ai_0
X_0933_ VGND VPWR VPWR VGND _0933_/CLK _0933_/D _0933_/RESET_B _0933_/Q sky130_fd_sc_hd__dfrtp_1
X_0580_ VPWR VGND VPWR VGND _0580_/A _0580_/C _0580_/D _0580_/Y _0580_/B sky130_fd_sc_hd__nand4_1
X_0916_ VPWR VGND VPWR VGND _0916_/B1 _0916_/A1 _0916_/A2 _0916_/X _0916_/B2 sky130_fd_sc_hd__a22o_1
X_0847_ VPWR VGND VGND VPWR _0847_/A _0847_/Y _0847_/B sky130_fd_sc_hd__nand2_1
X_0778_ VPWR VGND VGND VPWR _0778_/A _0778_/Y _0778_/B sky130_fd_sc_hd__nand2_1
X_0563_ VPWR VGND VGND VPWR _0563_/A _0563_/Y _0563_/B sky130_fd_sc_hd__nand2_1
X_0701_ VPWR VGND VGND VPWR _0701_/A _0701_/Y _0701_/B sky130_fd_sc_hd__nand2_1
X_0632_ VPWR VGND VGND VPWR _0632_/A _0632_/Y _0632_/B sky130_fd_sc_hd__nand2_1
X_0494_ VPWR VGND VGND VPWR _0494_/A _0494_/B _0494_/Y sky130_fd_sc_hd__nor2_1
X_0615_ VGND VPWR VGND VPWR _0615_/B1 _0615_/A1 _0615_/Y _0615_/A2 sky130_fd_sc_hd__o21ai_0
X_0546_ VPWR VGND VPWR VGND _0546_/B2 _0546_/B1 _0546_/Y _0546_/A1 _0546_/A2 sky130_fd_sc_hd__a22oi_1
X_0477_ VPWR VGND VGND VPWR _0477_/A _0477_/Y _0477_/B sky130_fd_sc_hd__nand2_1
X_1029_ _1029_/LO _1029_/HI VPWR VGND VGND VPWR sky130_fd_sc_hd__conb_1
X_0529_ VPWR VGND VGND VPWR _0529_/A _0529_/Y _0529_/B sky130_fd_sc_hd__nand2_1
XPHY_13 VPWR VGND VPWR VGND sky130_fd_sc_hd__decap_3
XPHY_24 VPWR VGND VPWR VGND sky130_fd_sc_hd__decap_3
XPHY_35 VPWR VGND VPWR VGND sky130_fd_sc_hd__decap_3
XPHY_46 VPWR VGND VPWR VGND sky130_fd_sc_hd__decap_3
XPHY_68 VPWR VGND VPWR VGND sky130_fd_sc_hd__decap_3
XPHY_57 VPWR VGND VPWR VGND sky130_fd_sc_hd__decap_3
X_0880_ VPWR VGND VGND VPWR _0880_/A _0880_/Y _0880_/B sky130_fd_sc_hd__nand2_1
X_0932_ VGND VPWR VPWR VGND _0932_/CLK _0932_/D _0932_/RESET_B _0932_/Q sky130_fd_sc_hd__dfrtp_1
X_0863_ VPWR VGND VGND VPWR _0863_/A _0863_/Y _0863_/B sky130_fd_sc_hd__nand2_1
X_0794_ VPWR VGND VGND VPWR _0794_/A _0794_/Y _0794_/B sky130_fd_sc_hd__nand2_1
X_0915_ VPWR VGND VGND VPWR _0915_/A _0915_/B _0915_/Y sky130_fd_sc_hd__nor2_1
X_0777_ VGND VPWR VGND VPWR _0777_/B1 _0777_/A1 _0777_/Y _0777_/A2 sky130_fd_sc_hd__o21ai_0
X_0846_ VPWR VGND VGND VPWR _0846_/A _0846_/Y _0846_/B sky130_fd_sc_hd__nand2_1
X_0700_ VPWR VGND VGND VPWR _0700_/A _0700_/Y _0700_/B sky130_fd_sc_hd__nand2_1
X_0562_ VPWR VGND VGND VPWR _0562_/A _0562_/Y _0562_/B sky130_fd_sc_hd__nand2_1
X_0631_ VPWR VGND VGND VPWR _0631_/A _0631_/Y _0631_/B sky130_fd_sc_hd__nand2_1
X_0493_ VPWR VGND VGND VPWR _0493_/A_N _0493_/B _0493_/Y sky130_fd_sc_hd__nand2b_1
X_0829_ VPWR VGND VGND VPWR _0829_/A _0829_/Y _0829_/B sky130_fd_sc_hd__nand2_1
X_0476_ VPWR VGND VGND VPWR _0476_/A _0476_/B _0476_/Y sky130_fd_sc_hd__nor2_1
X_0545_ VPWR VGND VGND VPWR _0545_/A1 _0545_/A2 _0545_/B1 _0545_/X sky130_fd_sc_hd__o21a_1
X_0614_ VPWR VGND VGND VPWR _0614_/A _0614_/Y _0614_/B sky130_fd_sc_hd__nand2_1
X_1028_ _1028_/LO _1028_/HI VPWR VGND VGND VPWR sky130_fd_sc_hd__conb_1
X_0459_ VPWR VGND VGND VPWR _0459_/A _0459_/B _0459_/Y sky130_fd_sc_hd__nor2_1
X_0528_ VPWR VGND VGND VPWR _0528_/A1 _0528_/A2 _0528_/B1 _0528_/X sky130_fd_sc_hd__o21a_1
XPHY_69 VPWR VGND VPWR VGND sky130_fd_sc_hd__decap_3
XPHY_58 VPWR VGND VPWR VGND sky130_fd_sc_hd__decap_3
XPHY_47 VPWR VGND VPWR VGND sky130_fd_sc_hd__decap_3
XPHY_14 VPWR VGND VPWR VGND sky130_fd_sc_hd__decap_3
XPHY_25 VPWR VGND VPWR VGND sky130_fd_sc_hd__decap_3
XPHY_36 VPWR VGND VPWR VGND sky130_fd_sc_hd__decap_3
X_0862_ VPWR VGND VGND VPWR _0862_/A _0862_/Y _0862_/B sky130_fd_sc_hd__nand2_1
X_0931_ VGND VPWR VPWR VGND _0931_/CLK _0931_/D _0931_/RESET_B _0931_/Q sky130_fd_sc_hd__dfrtp_1
X_0793_ VPWR VGND VGND VPWR _0793_/A _0793_/Y _0793_/B sky130_fd_sc_hd__nand2_1
X_0914_ VGND VPWR VGND VPWR _0914_/A1 _0914_/A2 _0914_/A3 _0914_/A4 _0914_/Y _0914_/B1
+ sky130_fd_sc_hd__o41ai_1
X_0845_ VPWR VGND VGND VPWR _0845_/A _0845_/Y _0845_/B sky130_fd_sc_hd__nand2_1
X_0776_ VPWR VGND VGND VPWR _0776_/A _0776_/Y _0776_/B sky130_fd_sc_hd__nand2_1
X_0561_ VGND VPWR VPWR VGND _0561_/X _0561_/B _0561_/A sky130_fd_sc_hd__and2_0
X_0492_ VPWR VGND VGND VPWR _0492_/A _0492_/B _0492_/Y sky130_fd_sc_hd__nor2_1
X_0630_ VGND VPWR VGND VPWR _0630_/B1 _0630_/A1 _0630_/Y _0630_/A2 sky130_fd_sc_hd__o21ai_0
X_0759_ VPWR VGND VGND VPWR _0759_/A _0759_/Y _0759_/B sky130_fd_sc_hd__nand2_1
X_0828_ VPWR VGND VGND VPWR _0828_/A _0828_/Y _0828_/B sky130_fd_sc_hd__nand2_1
X_0613_ VPWR VGND VGND VPWR _0613_/A _0613_/Y _0613_/B sky130_fd_sc_hd__nand2_1
X_0475_ VGND VPWR VGND VPWR _0475_/B1 _0475_/A1 _0475_/Y _0475_/A2 sky130_fd_sc_hd__o21ai_0
X_0544_ VPWR VGND VPWR VGND _0544_/A _0544_/C _0544_/D _0544_/Y _0544_/B sky130_fd_sc_hd__nand4_1
X_1027_ _1027_/Q _1027_/CLK _1027_/D VPWR VGND VPWR VGND sky130_fd_sc_hd__dfxtp_1
Xclkbuf_3_5__f_clk VGND VPWR VGND VPWR clkbuf_3_5__f_clk/A clkbuf_3_5__f_clk/X sky130_fd_sc_hd__clkbuf_16
X_0458_ VPWR VGND VGND VPWR _0458_/A _0458_/B _0458_/Y sky130_fd_sc_hd__nor2_1
X_0527_ VPWR VGND VPWR VGND _0527_/A _0527_/C _0527_/D _0527_/Y _0527_/B sky130_fd_sc_hd__nand4_1
XPHY_59 VPWR VGND VPWR VGND sky130_fd_sc_hd__decap_3
XPHY_48 VPWR VGND VPWR VGND sky130_fd_sc_hd__decap_3
XPHY_15 VPWR VGND VPWR VGND sky130_fd_sc_hd__decap_3
XPHY_26 VPWR VGND VPWR VGND sky130_fd_sc_hd__decap_3
XPHY_37 VPWR VGND VPWR VGND sky130_fd_sc_hd__decap_3
X_0861_ VGND VPWR VGND VPWR _0861_/B1 _0861_/A1 _0861_/Y _0861_/A2 sky130_fd_sc_hd__o21ai_0
X_0930_ VGND VPWR VPWR VGND _0930_/CLK _0930_/D _0930_/RESET_B _0930_/Q sky130_fd_sc_hd__dfrtp_1
X_0792_ VGND VPWR VGND VPWR _0792_/B1 _0792_/A1 _0792_/Y _0792_/A2 sky130_fd_sc_hd__o21ai_0
X_0913_ VPWR VGND VPWR VGND _0913_/A2 _0913_/A1 _0913_/B1 _0913_/Y sky130_fd_sc_hd__a21oi_1
X_0775_ VPWR VGND VGND VPWR _0775_/A _0775_/Y _0775_/B sky130_fd_sc_hd__nand2_1
X_0844_ VPWR VGND VGND VPWR _0844_/A _0844_/Y _0844_/B sky130_fd_sc_hd__nand2_1
X_0491_ VPWR VGND VGND VPWR _0491_/A _0491_/B _0491_/Y sky130_fd_sc_hd__nor2_1
X_0560_ VPWR VGND VGND VPWR _0560_/A1 _0560_/A2 _0560_/B1 _0560_/X sky130_fd_sc_hd__o21a_1
X_0758_ VPWR VGND VGND VPWR _0758_/A _0758_/Y _0758_/B sky130_fd_sc_hd__nand2_1
X_0827_ VPWR VGND VGND VPWR _0827_/A _0827_/Y _0827_/B sky130_fd_sc_hd__nand2_1
X_0689_ VPWR VGND VGND VPWR _0689_/A _0689_/Y _0689_/B sky130_fd_sc_hd__nand2_1
X_0612_ VGND VPWR VGND VPWR _0612_/B1 _0612_/A1 _0612_/Y _0612_/A2 sky130_fd_sc_hd__o21ai_0
X_0474_ VGND VPWR VPWR VGND _0474_/B2 _0474_/Y _0474_/B1 _0474_/A1 _0474_/A2 _0474_/A3
+ sky130_fd_sc_hd__a32oi_1
X_0543_ VPWR VGND VPWR VGND _0543_/B2 _0543_/B1 _0543_/Y _0543_/A1 _0543_/A2 sky130_fd_sc_hd__a22oi_1
X_1026_ _1026_/Q _1026_/CLK _1026_/D VPWR VGND VPWR VGND sky130_fd_sc_hd__dfxtp_1
X_0526_ VGND VPWR VPWR VGND _0526_/C2 _0526_/C1 _0526_/B1 _0526_/A2 _0526_/A1 _0526_/Y
+ _0526_/B2 sky130_fd_sc_hd__a222oi_1
X_0457_ VPWR VGND VGND VPWR _0457_/A _0457_/Y _0457_/B sky130_fd_sc_hd__nand2_1
XPHY_49 VPWR VGND VPWR VGND sky130_fd_sc_hd__decap_3
XPHY_16 VPWR VGND VPWR VGND sky130_fd_sc_hd__decap_3
X_1009_ VGND VPWR VPWR VGND _1009_/CLK _1009_/D _1009_/RESET_B _1009_/Q sky130_fd_sc_hd__dfrtp_1
XPHY_27 VPWR VGND VPWR VGND sky130_fd_sc_hd__decap_3
XPHY_38 VPWR VGND VPWR VGND sky130_fd_sc_hd__decap_3
X_0509_ VPWR VGND VPWR VGND _0509_/B2 _0509_/B1 _0509_/Y _0509_/A1 _0509_/A2 sky130_fd_sc_hd__a22oi_1
X_0860_ VPWR VGND VGND VPWR _0860_/A _0860_/Y _0860_/B sky130_fd_sc_hd__nand2_1
X_0791_ VPWR VGND VGND VPWR _0791_/A _0791_/Y _0791_/B sky130_fd_sc_hd__nand2_1
X_0989_ VGND VPWR VPWR VGND _0989_/CLK _0989_/D _0989_/RESET_B _0989_/Q sky130_fd_sc_hd__dfrtp_1
X_0912_ VPWR VGND VGND VPWR _0912_/A _0912_/Y _0912_/B sky130_fd_sc_hd__nand2_1
X_0774_ VGND VPWR VGND VPWR _0774_/B1 _0774_/A1 _0774_/Y _0774_/A2 sky130_fd_sc_hd__o21ai_0
X_0843_ VGND VPWR VGND VPWR _0843_/B1 _0843_/A1 _0843_/Y _0843_/A2 sky130_fd_sc_hd__o21ai_0
X_0490_ VPWR VGND VGND VPWR _0490_/A_N _0490_/B _0490_/Y sky130_fd_sc_hd__nand2b_1
X_0688_ VPWR VGND VGND VPWR _0688_/A _0688_/Y _0688_/B sky130_fd_sc_hd__nand2_1
X_0757_ VPWR VGND VGND VPWR _0757_/A _0757_/Y _0757_/B sky130_fd_sc_hd__nand2_1
X_0826_ VPWR VGND VGND VPWR _0826_/A _0826_/Y _0826_/B sky130_fd_sc_hd__nand2_1
X_0611_ VPWR VGND VGND VPWR _0611_/A _0611_/Y _0611_/B sky130_fd_sc_hd__nand2_1
X_0542_ VPWR VGND VPWR VGND _0542_/B2 _0542_/B1 _0542_/Y _0542_/A1 _0542_/A2 sky130_fd_sc_hd__a22oi_1
X_0473_ VGND VPWR VPWR VGND _0473_/X _0473_/B _0473_/A sky130_fd_sc_hd__and2_0
X_1025_ _1025_/Q _1025_/CLK _1025_/D VPWR VGND VPWR VGND sky130_fd_sc_hd__dfxtp_1
X_0809_ VPWR VGND VGND VPWR _0809_/A _0809_/Y _0809_/B sky130_fd_sc_hd__nand2_1
X_0456_ VPWR VGND VGND VPWR _0456_/A _0456_/Y sky130_fd_sc_hd__clkinv_1
X_0525_ VGND VPWR VPWR VGND _0525_/C2 _0525_/C1 _0525_/B1 _0525_/A2 _0525_/A1 _0525_/Y
+ _0525_/B2 sky130_fd_sc_hd__a222oi_1
XPHY_17 VPWR VGND VPWR VGND sky130_fd_sc_hd__decap_3
XPHY_28 VPWR VGND VPWR VGND sky130_fd_sc_hd__decap_3
X_1008_ VGND VPWR VPWR VGND _1008_/CLK _1008_/D _1008_/RESET_B _1008_/Q sky130_fd_sc_hd__dfrtp_1
XPHY_39 VPWR VGND VPWR VGND sky130_fd_sc_hd__decap_3
X_0508_ VPWR VGND VPWR VGND _0508_/B1 _0508_/A1 _0508_/A2 _0508_/X _0508_/B2 sky130_fd_sc_hd__a22o_1
X_0790_ VPWR VGND VGND VPWR _0790_/A _0790_/Y _0790_/B sky130_fd_sc_hd__nand2_1
X_0988_ VGND VPWR VPWR VGND _0988_/CLK _0988_/D _0988_/RESET_B _0988_/Q sky130_fd_sc_hd__dfrtp_1
X_0911_ VPWR VGND VPWR VGND _0911_/B1 _0911_/A1 _0911_/A2 _0911_/X _0911_/B2 sky130_fd_sc_hd__a22o_1
X_0842_ VPWR VGND VGND VPWR _0842_/A _0842_/Y _0842_/B sky130_fd_sc_hd__nand2_1
X_0773_ VPWR VGND VGND VPWR _0773_/A _0773_/Y _0773_/B sky130_fd_sc_hd__nand2_1
X_0825_ VGND VPWR VGND VPWR _0825_/B1 _0825_/A1 _0825_/Y _0825_/A2 sky130_fd_sc_hd__o21ai_0
X_0687_ VGND VPWR VGND VPWR _0687_/B1 _0687_/A1 _0687_/Y _0687_/A2 sky130_fd_sc_hd__o21ai_0
X_0756_ VPWR VGND VGND VPWR _0756_/A _0756_/Y _0756_/B sky130_fd_sc_hd__nand2_1
X_0472_ VPWR VGND VGND VPWR _0472_/A _0472_/B _0472_/Y _0472_/C sky130_fd_sc_hd__nand3_1
X_0610_ VPWR VGND VGND VPWR _0610_/A _0610_/Y _0610_/B sky130_fd_sc_hd__nand2_1
X_0541_ VGND VPWR VPWR VGND _0541_/C2 _0541_/C1 _0541_/B1 _0541_/A2 _0541_/A1 _0541_/Y
+ _0541_/B2 sky130_fd_sc_hd__a222oi_1
X_1024_ _1024_/Q _1024_/CLK _1024_/D VPWR VGND VPWR VGND sky130_fd_sc_hd__dfxtp_1
X_0808_ VPWR VGND VGND VPWR _0808_/A _0808_/Y _0808_/B sky130_fd_sc_hd__nand2_1
X_0739_ VPWR VGND VGND VPWR _0739_/A _0739_/Y _0739_/B sky130_fd_sc_hd__nand2_1
X_0455_ VPWR VGND VGND VPWR _0455_/A _0455_/Y _0455_/B sky130_fd_sc_hd__nand2_1
X_0524_ VPWR VGND VPWR VGND _0524_/B2 _0524_/B1 _0524_/Y _0524_/A1 _0524_/A2 sky130_fd_sc_hd__a22oi_1
XPHY_18 VPWR VGND VPWR VGND sky130_fd_sc_hd__decap_3
X_1007_ VGND VPWR VPWR VGND _1007_/CLK _1007_/D _1007_/RESET_B _1007_/Q sky130_fd_sc_hd__dfrtp_1
XPHY_29 VPWR VGND VPWR VGND sky130_fd_sc_hd__decap_3
X_0507_ VPWR VGND VPWR VGND _0507_/B2 _0507_/B1 _0507_/Y _0507_/A1 _0507_/A2 sky130_fd_sc_hd__a22oi_1
X_0987_ VGND VPWR VPWR VGND _0987_/CLK _0987_/D _0987_/RESET_B _0987_/Q sky130_fd_sc_hd__dfrtp_1
X_0910_ VGND VPWR _0910_/B _0910_/Y _0910_/A VPWR VGND sky130_fd_sc_hd__xnor2_1
X_0772_ VPWR VGND VGND VPWR _0772_/A _0772_/Y _0772_/B sky130_fd_sc_hd__nand2_1
X_0841_ VPWR VGND VGND VPWR _0841_/A _0841_/Y _0841_/B sky130_fd_sc_hd__nand2_1
X_0755_ VPWR VGND VGND VPWR _0755_/A _0755_/Y _0755_/B sky130_fd_sc_hd__nand2_1
X_0824_ VPWR VGND VGND VPWR _0824_/A _0824_/Y _0824_/B sky130_fd_sc_hd__nand2_1
X_0686_ VPWR VGND VGND VPWR _0686_/A _0686_/Y _0686_/B sky130_fd_sc_hd__nand2_1
Xclkbuf_3_0__f_clk VGND VPWR VGND VPWR clkbuf_3_0__f_clk/A clkbuf_3_0__f_clk/X sky130_fd_sc_hd__clkbuf_16
X_0471_ VPWR VGND VGND VPWR _0471_/A _0471_/Y _0471_/B sky130_fd_sc_hd__nand2_1
X_0540_ VPWR VGND VGND VPWR _0540_/A _0540_/Y _0540_/B sky130_fd_sc_hd__nand2_1
X_1023_ _1023_/Q _1023_/CLK _1023_/D VPWR VGND VPWR VGND sky130_fd_sc_hd__dfxtp_1
X_0738_ VGND VPWR VGND VPWR _0738_/B1 _0738_/A1 _0738_/Y _0738_/A2 sky130_fd_sc_hd__o21ai_0
X_0807_ VGND VPWR VGND VPWR _0807_/B1 _0807_/A1 _0807_/Y _0807_/A2 sky130_fd_sc_hd__o21ai_0
X_0669_ VGND VPWR VGND VPWR _0669_/B1 _0669_/A1 _0669_/Y _0669_/A2 sky130_fd_sc_hd__o21ai_0
X_0454_ VPWR VGND VGND VPWR _0454_/A _0454_/SLEEP _0454_/X sky130_fd_sc_hd__lpflow_isobufsrc_1
X_0523_ VPWR VGND VPWR VGND _0523_/B1 _0523_/A1 _0523_/A2 _0523_/X _0523_/B2 sky130_fd_sc_hd__a22o_1
XPHY_19 VPWR VGND VPWR VGND sky130_fd_sc_hd__decap_3
X_1006_ VGND VPWR VPWR VGND _1006_/CLK _1006_/D _1006_/RESET_B _1006_/Q sky130_fd_sc_hd__dfrtp_1
X_0506_ VPWR VGND VGND VPWR _0506_/A1 _0506_/A2 _0506_/B1 _0506_/X sky130_fd_sc_hd__o21a_1
X_0986_ VGND VPWR VPWR VGND _0986_/CLK _0986_/D _0986_/RESET_B _0986_/Q sky130_fd_sc_hd__dfrtp_1
X_0771_ VGND VPWR VGND VPWR _0771_/B1 _0771_/A1 _0771_/Y _0771_/A2 sky130_fd_sc_hd__o21ai_0
X_0840_ VPWR VGND VGND VPWR _0840_/A _0840_/Y _0840_/B sky130_fd_sc_hd__nand2_1
X_0969_ VGND VPWR VPWR VGND _0969_/CLK _0969_/D _0969_/RESET_B _0969_/Q sky130_fd_sc_hd__dfrtp_1
X_0685_ VPWR VGND VGND VPWR _0685_/A _0685_/Y _0685_/B sky130_fd_sc_hd__nand2_1
X_0754_ VPWR VGND VGND VPWR _0754_/A _0754_/Y _0754_/B sky130_fd_sc_hd__nand2_1
X_0823_ VPWR VGND VGND VPWR _0823_/A _0823_/Y _0823_/B sky130_fd_sc_hd__nand2_1
X_0470_ VGND VPWR _0470_/B _0470_/Y _0470_/A VPWR VGND sky130_fd_sc_hd__xnor2_1
X_1022_ _1022_/Q _1022_/CLK _1022_/D VPWR VGND VPWR VGND sky130_fd_sc_hd__dfxtp_1
X_0737_ VPWR VGND VGND VPWR _0737_/A _0737_/Y _0737_/B sky130_fd_sc_hd__nand2_1
X_0668_ VPWR VGND VGND VPWR _0668_/A _0668_/Y _0668_/B sky130_fd_sc_hd__nand2_1
X_0806_ VPWR VGND VGND VPWR _0806_/A _0806_/Y _0806_/B sky130_fd_sc_hd__nand2_1
X_0599_ VPWR VGND VGND VPWR _0599_/Y _0599_/C _0599_/B _0599_/D _0599_/A_N sky130_fd_sc_hd__nand4b_1
X_0522_ VPWR VGND VPWR VGND _0522_/B2 _0522_/B1 _0522_/Y _0522_/A1 _0522_/A2 sky130_fd_sc_hd__a22oi_1
X_0453_ VPWR VGND VGND VPWR _0453_/A _0453_/SLEEP _0453_/X sky130_fd_sc_hd__lpflow_isobufsrc_1
X_1005_ VGND VPWR VPWR VGND _1005_/CLK _1005_/D _1005_/RESET_B _1005_/Q sky130_fd_sc_hd__dfrtp_1
X_0505_ VPWR VGND VGND VPWR _0505_/A _0505_/B _0505_/Y _0505_/C sky130_fd_sc_hd__nand3_1
.ends
