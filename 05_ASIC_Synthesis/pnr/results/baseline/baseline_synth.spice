* SPICE netlist generated by Yosys 0.52 (git sha1 fee39a3284c90249e1d9684cf6944ffbbcbb8f90)

.SUBCKT tt_um_dusterthefirst_project ui_in.0 ui_in.1 ui_in.2 ui_in.3 ui_in.4 ui_in.5 ui_in.6 ui_in.7 uo_out.0 uo_out.1 uo_out.2 uo_out.3 uo_out.4 uo_out.5 uo_out.6 uo_out.7 uio_in.0 uio_in.1 uio_in.2 uio_in.3 uio_in.4 uio_in.5 uio_in.6 uio_in.7 uio_out.0 uio_out.1 uio_out.2 uio_out.3 uio_out.4 uio_out.5 uio_out.6 uio_out.7 uio_oe.0 uio_oe.1 uio_oe.2 uio_oe.3 uio_oe.4 uio_oe.5 uio_oe.6 uio_oe.7 ena clk rst_n
X0 _NC0 uio_out.7 sky130_fd_sc_hd__conb_1
X1 _NC1 uio_out.6 sky130_fd_sc_hd__conb_1
X2 uio_oe.7 _NC2 sky130_fd_sc_hd__conb_1
X3 uio_oe.6 _NC3 sky130_fd_sc_hd__conb_1
X4 uio_oe.5 _NC4 sky130_fd_sc_hd__conb_1
X5 uio_oe.4 _NC5 sky130_fd_sc_hd__conb_1
X6 uio_oe.3 _NC6 sky130_fd_sc_hd__conb_1
X7 uio_oe.2 _NC7 sky130_fd_sc_hd__conb_1
X8 uio_oe.1 _NC8 sky130_fd_sc_hd__conb_1
X9 uio_oe.0 _NC9 sky130_fd_sc_hd__conb_1
X10 clk _0109_ input_edge_detect.previous_in sky130_fd_sc_hd__dfxtp_1
X11 clk _0108_ uio_out.3 sky130_fd_sc_hd__dfxtp_1
X12 clk _0107_ state_machine.timer.3 sky130_fd_sc_hd__dfxtp_1
X13 clk _0106_ state_machine.timer.2 sky130_fd_sc_hd__dfxtp_1
X14 clk _0105_ state_machine.timer.1 sky130_fd_sc_hd__dfxtp_1
X15 clk _0104_ state_machine.timer.0 sky130_fd_sc_hd__dfxtp_1
X16 clk _0103_ uio_out.2 sky130_fd_sc_hd__dfxtp_1
X17 clk _0102_ uio_out.1 sky130_fd_sc_hd__dfxtp_1
X18 clk _0003_ state_machine.state.3 sky130_fd_sc_hd__dfxtp_1
X19 clk _0002_ state_machine.state.2 sky130_fd_sc_hd__dfxtp_1
X20 clk _0001_ state_machine.state.1 sky130_fd_sc_hd__dfxtp_1
X21 clk _0000_ state_machine.state.0 sky130_fd_sc_hd__dfxtp_1
X22 clk _0101_ data_multiplex.serial_decode.preamble_or_data data_multiplex.reset_n sky130_fd_sc_hd__dfrtp_1
X23 clk _0100_ data_multiplex.serial_decode.shift_register.96 data_multiplex.reset_n sky130_fd_sc_hd__dfrtp_1
X24 clk _0099_ data_multiplex.serial_decode.data_validate.preamble.31 data_multiplex.reset_n sky130_fd_sc_hd__dfrtp_1
X25 clk _0098_ data_multiplex.serial_decode.data_validate.preamble.30 data_multiplex.reset_n sky130_fd_sc_hd__dfrtp_1
X26 clk _0097_ data_multiplex.serial_decode.data_validate.preamble.29 data_multiplex.reset_n sky130_fd_sc_hd__dfrtp_1
X27 clk _0096_ data_multiplex.serial_decode.data_validate.preamble.28 data_multiplex.reset_n sky130_fd_sc_hd__dfrtp_1
X28 clk _0095_ data_multiplex.serial_decode.data_validate.preamble.27 data_multiplex.reset_n sky130_fd_sc_hd__dfrtp_1
X29 clk _0094_ data_multiplex.serial_decode.data_validate.preamble.26 data_multiplex.reset_n sky130_fd_sc_hd__dfrtp_1
X30 clk _0093_ data_multiplex.serial_decode.data_validate.preamble.25 data_multiplex.reset_n sky130_fd_sc_hd__dfrtp_1
X31 clk _0092_ data_multiplex.serial_decode.data_validate.preamble.24 data_multiplex.reset_n sky130_fd_sc_hd__dfrtp_1
X32 clk _0091_ data_multiplex.serial_decode.data_validate.preamble.23 data_multiplex.reset_n sky130_fd_sc_hd__dfrtp_1
X33 clk _0090_ data_multiplex.serial_decode.data_validate.preamble.22 data_multiplex.reset_n sky130_fd_sc_hd__dfrtp_1
X34 clk _0089_ data_multiplex.serial_decode.data_validate.preamble.21 data_multiplex.reset_n sky130_fd_sc_hd__dfrtp_1
X35 clk _0088_ data_multiplex.serial_decode.data_validate.preamble.20 data_multiplex.reset_n sky130_fd_sc_hd__dfrtp_1
X36 clk _0087_ data_multiplex.serial_decode.data_validate.preamble.19 data_multiplex.reset_n sky130_fd_sc_hd__dfrtp_1
X37 clk _0086_ data_multiplex.serial_decode.data_validate.preamble.18 data_multiplex.reset_n sky130_fd_sc_hd__dfrtp_1
X38 clk _0085_ data_multiplex.serial_decode.data_validate.preamble.17 data_multiplex.reset_n sky130_fd_sc_hd__dfrtp_1
X39 clk _0084_ data_multiplex.serial_decode.data_validate.preamble.16 data_multiplex.reset_n sky130_fd_sc_hd__dfrtp_1
X40 clk _0083_ data_multiplex.serial_decode.data_validate.preamble.15 data_multiplex.reset_n sky130_fd_sc_hd__dfrtp_1
X41 clk _0082_ data_multiplex.serial_decode.data_validate.preamble.14 data_multiplex.reset_n sky130_fd_sc_hd__dfrtp_1
X42 clk _0081_ data_multiplex.serial_decode.data_validate.preamble.13 data_multiplex.reset_n sky130_fd_sc_hd__dfrtp_1
X43 clk _0080_ data_multiplex.serial_decode.data_validate.preamble.12 data_multiplex.reset_n sky130_fd_sc_hd__dfrtp_1
X44 clk _0079_ data_multiplex.serial_decode.data_validate.preamble.11 data_multiplex.reset_n sky130_fd_sc_hd__dfrtp_1
X45 clk _0078_ data_multiplex.serial_decode.data_validate.preamble.10 data_multiplex.reset_n sky130_fd_sc_hd__dfrtp_1
X46 clk _0077_ data_multiplex.serial_decode.data_validate.preamble.9 data_multiplex.reset_n sky130_fd_sc_hd__dfrtp_1
X47 clk _0076_ data_multiplex.serial_decode.data_validate.preamble.8 data_multiplex.reset_n sky130_fd_sc_hd__dfrtp_1
X48 clk _0075_ data_multiplex.serial_decode.data_validate.preamble.7 data_multiplex.reset_n sky130_fd_sc_hd__dfrtp_1
X49 clk _0074_ data_multiplex.serial_decode.data_validate.preamble.6 data_multiplex.reset_n sky130_fd_sc_hd__dfrtp_1
X50 clk _0073_ data_multiplex.serial_decode.data_validate.preamble.5 data_multiplex.reset_n sky130_fd_sc_hd__dfrtp_1
X51 clk _0072_ data_multiplex.serial_decode.data_validate.preamble.4 data_multiplex.reset_n sky130_fd_sc_hd__dfrtp_1
X52 clk _0071_ data_multiplex.serial_decode.data_validate.preamble.3 data_multiplex.reset_n sky130_fd_sc_hd__dfrtp_1
X53 clk _0070_ data_multiplex.serial_decode.data_validate.preamble.2 data_multiplex.reset_n sky130_fd_sc_hd__dfrtp_1
X54 clk _0069_ data_multiplex.serial_decode.data_validate.preamble.1 data_multiplex.reset_n sky130_fd_sc_hd__dfrtp_1
X55 clk _0068_ data_multiplex.serial_decode.data_validate.preamble.0 data_multiplex.reset_n sky130_fd_sc_hd__dfrtp_1
X56 clk _0067_ data_multiplex.room_temp.15 data_multiplex.reset_n sky130_fd_sc_hd__dfrtp_1
X57 clk _0066_ data_multiplex.room_temp.14 data_multiplex.reset_n sky130_fd_sc_hd__dfrtp_1
X58 clk _0065_ data_multiplex.room_temp.13 data_multiplex.reset_n sky130_fd_sc_hd__dfrtp_1
X59 clk _0064_ data_multiplex.room_temp.12 data_multiplex.reset_n sky130_fd_sc_hd__dfrtp_1
X60 clk _0063_ data_multiplex.room_temp.11 data_multiplex.reset_n sky130_fd_sc_hd__dfrtp_1
X61 clk _0062_ data_multiplex.room_temp.10 data_multiplex.reset_n sky130_fd_sc_hd__dfrtp_1
X62 clk _0061_ data_multiplex.room_temp.9 data_multiplex.reset_n sky130_fd_sc_hd__dfrtp_1
X63 clk _0060_ data_multiplex.room_temp.8 data_multiplex.reset_n sky130_fd_sc_hd__dfrtp_1
X64 clk _0059_ data_multiplex.room_temp.7 data_multiplex.reset_n sky130_fd_sc_hd__dfrtp_1
X65 clk _0058_ data_multiplex.room_temp.6 data_multiplex.reset_n sky130_fd_sc_hd__dfrtp_1
X66 clk _0057_ data_multiplex.room_temp.5 data_multiplex.reset_n sky130_fd_sc_hd__dfrtp_1
X67 clk _0056_ data_multiplex.room_temp.4 data_multiplex.reset_n sky130_fd_sc_hd__dfrtp_1
X68 clk _0055_ data_multiplex.room_temp.3 data_multiplex.reset_n sky130_fd_sc_hd__dfrtp_1
X69 clk _0054_ data_multiplex.room_temp.2 data_multiplex.reset_n sky130_fd_sc_hd__dfrtp_1
X70 clk _0053_ data_multiplex.room_temp.1 data_multiplex.reset_n sky130_fd_sc_hd__dfrtp_1
X71 clk _0052_ data_multiplex.room_temp.0 data_multiplex.reset_n sky130_fd_sc_hd__dfrtp_1
X72 clk _0051_ data_multiplex.serial_decode.data_validate.type_2.15 data_multiplex.reset_n sky130_fd_sc_hd__dfrtp_1
X73 clk _0050_ data_multiplex.serial_decode.data_validate.type_2.14 data_multiplex.reset_n sky130_fd_sc_hd__dfrtp_1
X74 clk _0049_ data_multiplex.serial_decode.data_validate.type_2.13 data_multiplex.reset_n sky130_fd_sc_hd__dfrtp_1
X75 clk _0048_ data_multiplex.serial_decode.data_validate.type_2.12 data_multiplex.reset_n sky130_fd_sc_hd__dfrtp_1
X76 clk _0047_ data_multiplex.serial_decode.data_validate.type_2.11 data_multiplex.reset_n sky130_fd_sc_hd__dfrtp_1
X77 clk _0046_ data_multiplex.serial_decode.data_validate.type_2.10 data_multiplex.reset_n sky130_fd_sc_hd__dfrtp_1
X78 clk _0045_ data_multiplex.serial_decode.data_validate.type_2.9 data_multiplex.reset_n sky130_fd_sc_hd__dfrtp_1
X79 clk _0044_ data_multiplex.serial_decode.data_validate.type_2.8 data_multiplex.reset_n sky130_fd_sc_hd__dfrtp_1
X80 clk _0043_ data_multiplex.serial_decode.data_validate.type_2.7 data_multiplex.reset_n sky130_fd_sc_hd__dfrtp_1
X81 clk _0042_ data_multiplex.serial_decode.data_validate.type_2.6 data_multiplex.reset_n sky130_fd_sc_hd__dfrtp_1
X82 clk _0041_ data_multiplex.serial_decode.data_validate.type_2.5 data_multiplex.reset_n sky130_fd_sc_hd__dfrtp_1
X83 clk _0040_ data_multiplex.serial_decode.data_validate.type_2.4 data_multiplex.reset_n sky130_fd_sc_hd__dfrtp_1
X84 clk _0039_ data_multiplex.serial_decode.data_validate.type_2.3 data_multiplex.reset_n sky130_fd_sc_hd__dfrtp_1
X85 clk _0038_ data_multiplex.serial_decode.data_validate.type_2.2 data_multiplex.reset_n sky130_fd_sc_hd__dfrtp_1
X86 clk _0037_ data_multiplex.serial_decode.data_validate.type_2.1 data_multiplex.reset_n sky130_fd_sc_hd__dfrtp_1
X87 clk _0036_ data_multiplex.serial_decode.data_validate.type_2.0 data_multiplex.reset_n sky130_fd_sc_hd__dfrtp_1
X88 clk _0035_ data_multiplex.serial_decode.constant.31 data_multiplex.reset_n sky130_fd_sc_hd__dfrtp_1
X89 clk _0034_ data_multiplex.serial_decode.constant.30 data_multiplex.reset_n sky130_fd_sc_hd__dfrtp_1
X90 clk _0033_ data_multiplex.serial_decode.constant.29 data_multiplex.reset_n sky130_fd_sc_hd__dfrtp_1
X91 clk _0032_ data_multiplex.serial_decode.constant.28 data_multiplex.reset_n sky130_fd_sc_hd__dfrtp_1
X92 clk _0031_ data_multiplex.serial_decode.constant.27 data_multiplex.reset_n sky130_fd_sc_hd__dfrtp_1
X93 clk _0030_ data_multiplex.serial_decode.constant.26 data_multiplex.reset_n sky130_fd_sc_hd__dfrtp_1
X94 clk _0029_ data_multiplex.serial_decode.constant.25 data_multiplex.reset_n sky130_fd_sc_hd__dfrtp_1
X95 clk _0028_ data_multiplex.serial_decode.constant.24 data_multiplex.reset_n sky130_fd_sc_hd__dfrtp_1
X96 clk _0027_ data_multiplex.serial_decode.constant.23 data_multiplex.reset_n sky130_fd_sc_hd__dfrtp_1
X97 clk _0026_ data_multiplex.serial_decode.constant.22 data_multiplex.reset_n sky130_fd_sc_hd__dfrtp_1
X98 clk _0025_ data_multiplex.serial_decode.constant.21 data_multiplex.reset_n sky130_fd_sc_hd__dfrtp_1
X99 clk _0024_ data_multiplex.serial_decode.constant.20 data_multiplex.reset_n sky130_fd_sc_hd__dfrtp_1
X100 clk _0023_ data_multiplex.serial_decode.constant.19 data_multiplex.reset_n sky130_fd_sc_hd__dfrtp_1
X101 clk _0022_ data_multiplex.serial_decode.constant.18 data_multiplex.reset_n sky130_fd_sc_hd__dfrtp_1
X102 clk _0021_ data_multiplex.serial_decode.constant.17 data_multiplex.reset_n sky130_fd_sc_hd__dfrtp_1
X103 clk _0020_ data_multiplex.serial_decode.constant.16 data_multiplex.reset_n sky130_fd_sc_hd__dfrtp_1
X104 clk _0019_ data_multiplex.serial_decode.constant.15 data_multiplex.reset_n sky130_fd_sc_hd__dfrtp_1
X105 clk _0018_ data_multiplex.serial_decode.constant.14 data_multiplex.reset_n sky130_fd_sc_hd__dfrtp_1
X106 clk _0017_ data_multiplex.serial_decode.constant.13 data_multiplex.reset_n sky130_fd_sc_hd__dfrtp_1
X107 clk _0016_ data_multiplex.serial_decode.constant.12 data_multiplex.reset_n sky130_fd_sc_hd__dfrtp_1
X108 clk _0015_ data_multiplex.serial_decode.constant.11 data_multiplex.reset_n sky130_fd_sc_hd__dfrtp_1
X109 clk _0014_ data_multiplex.serial_decode.constant.10 data_multiplex.reset_n sky130_fd_sc_hd__dfrtp_1
X110 clk _0013_ data_multiplex.serial_decode.constant.9 data_multiplex.reset_n sky130_fd_sc_hd__dfrtp_1
X111 clk _0012_ data_multiplex.serial_decode.constant.8 data_multiplex.reset_n sky130_fd_sc_hd__dfrtp_1
X112 clk _0011_ data_multiplex.serial_decode.constant.7 data_multiplex.reset_n sky130_fd_sc_hd__dfrtp_1
X113 clk _0010_ data_multiplex.serial_decode.constant.6 data_multiplex.reset_n sky130_fd_sc_hd__dfrtp_1
X114 clk _0009_ data_multiplex.serial_decode.constant.5 data_multiplex.reset_n sky130_fd_sc_hd__dfrtp_1
X115 clk _0008_ data_multiplex.serial_decode.constant.4 data_multiplex.reset_n sky130_fd_sc_hd__dfrtp_1
X116 clk _0007_ data_multiplex.serial_decode.constant.3 data_multiplex.reset_n sky130_fd_sc_hd__dfrtp_1
X117 clk _0006_ data_multiplex.serial_decode.constant.2 data_multiplex.reset_n sky130_fd_sc_hd__dfrtp_1
X118 clk _0005_ data_multiplex.serial_decode.constant.1 data_multiplex.reset_n sky130_fd_sc_hd__dfrtp_1
X119 clk _0004_ data_multiplex.serial_decode.constant.0 data_multiplex.reset_n sky130_fd_sc_hd__dfstp_2
X120 ui_in.0 rst_n _0109_ sky130_fd_sc_hd__and2_0
X121 _0108_ uio_out.3 _0126_ _0452_ _0119_ sky130_fd_sc_hd__a22o_1
X122 state_machine.state.1 _0436_ _0452_ sky130_fd_sc_hd__nor2_1
X123 _0107_ _0112_ _0118_ _0450_ _0125_ _0451_ sky130_fd_sc_hd__o41ai_1
X124 _0451_ state_machine.timer.1 state_machine.timer.0 _0121_ sky130_fd_sc_hd__a21oi_1
X125 state_machine.timer.3 _0126_ _0450_ sky130_fd_sc_hd__nand2_1
X126 _0106_ state_machine.timer.2 _0126_ _0444_ _0449_ sky130_fd_sc_hd__a22o_1
X127 state_machine.timer.2 _0446_ _0449_ sky130_fd_sc_hd__xnor2_1
X128 _0105_ _0443_ _0448_ _0445_ sky130_fd_sc_hd__o21ai_0
X129 _0446_ _0447_ _0448_ sky130_fd_sc_hd__nand2_1
X130 _0114_ _0118_ _0447_ sky130_fd_sc_hd__nor2_1
X131 state_machine.timer.1 state_machine.timer.0 _0446_ sky130_fd_sc_hd__nand2_1
X132 state_machine.timer.1 _0126_ _0445_ sky130_fd_sc_hd__nand2_1
X133 state_machine.timer.0 _0104_ _0126_ _0444_ sky130_fd_sc_hd__mux2_1
X134 _0444_ _0442_ _0443_ _0118_ sky130_fd_sc_hd__a21oi_1
X135 _0443_ _0112_ _0436_ _0125_ sky130_fd_sc_hd__a21boi_0
X136 state_machine.state.2 _0115_ _0442_ sky130_fd_sc_hd__nand2_1
X137 _0439_ _0441_ _0103_ sky130_fd_sc_hd__nor2_1
X138 rst_n _0440_ _0441_ sky130_fd_sc_hd__nand2_1
X139 uio_out.5 _0438_ _0440_ sky130_fd_sc_hd__nand2_1
X140 _0439_ _0124_ _0438_ uio_out.2 sky130_fd_sc_hd__a21oi_1
X141 ui_in.2 state_machine.state.0 _0436_ _0438_ sky130_fd_sc_hd__nor3_1
X142 _0102_ state_machine.state.0 _0118_ _0437_ _0123_ _0436_ sky130_fd_sc_hd__o41ai_1
X143 uio_out.1 _0126_ _0437_ sky130_fd_sc_hd__nand2_1
X144 state_machine.state.2 _0436_ state_machine.state.3 sky130_fd_sc_hd__lpflow_inputiso1p_1
X145 _0101_ uio_out.1 _0245_ data_multiplex.serial_decode.preamble_or_data sky130_fd_sc_hd__a21o_1
X146 _0100_ _0245_ _0434_ _0435_ sky130_fd_sc_hd__o21ai_0
X147 data_multiplex.serial_decode.shift_register.96 _0203_ _0435_ sky130_fd_sc_hd__nand2_1
X148 data_multiplex.serial_decode.data_validate.preamble.31 _0202_ _0434_ sky130_fd_sc_hd__nand2_1
X149 _0432_ _0433_ _0099_ sky130_fd_sc_hd__nand2_1
X150 data_multiplex.serial_decode.data_validate.preamble.31 _0203_ _0433_ sky130_fd_sc_hd__nand2_1
X151 data_multiplex.serial_decode.data_validate.preamble.30 _0202_ _0432_ sky130_fd_sc_hd__nand2_1
X152 _0098_ _0245_ _0430_ _0431_ sky130_fd_sc_hd__o21ai_0
X153 data_multiplex.serial_decode.data_validate.preamble.30 _0203_ _0431_ sky130_fd_sc_hd__nand2_1
X154 data_multiplex.serial_decode.data_validate.preamble.29 _0202_ _0430_ sky130_fd_sc_hd__nand2_1
X155 _0428_ _0429_ _0097_ sky130_fd_sc_hd__nand2_1
X156 data_multiplex.serial_decode.data_validate.preamble.29 _0203_ _0429_ sky130_fd_sc_hd__nand2_1
X157 data_multiplex.serial_decode.data_validate.preamble.28 _0202_ _0428_ sky130_fd_sc_hd__nand2_1
X158 _0096_ _0245_ _0426_ _0427_ sky130_fd_sc_hd__o21ai_0
X159 data_multiplex.serial_decode.data_validate.preamble.28 _0203_ _0427_ sky130_fd_sc_hd__nand2_1
X160 data_multiplex.serial_decode.data_validate.preamble.27 _0202_ _0426_ sky130_fd_sc_hd__nand2_1
X161 _0424_ _0425_ _0095_ sky130_fd_sc_hd__nand2_1
X162 data_multiplex.serial_decode.data_validate.preamble.27 _0203_ _0425_ sky130_fd_sc_hd__nand2_1
X163 data_multiplex.serial_decode.data_validate.preamble.26 _0202_ _0424_ sky130_fd_sc_hd__nand2_1
X164 _0094_ _0245_ _0422_ _0423_ sky130_fd_sc_hd__o21ai_0
X165 data_multiplex.serial_decode.data_validate.preamble.26 _0203_ _0423_ sky130_fd_sc_hd__nand2_1
X166 data_multiplex.serial_decode.data_validate.preamble.25 _0202_ _0422_ sky130_fd_sc_hd__nand2_1
X167 _0420_ _0421_ _0093_ sky130_fd_sc_hd__nand2_1
X168 data_multiplex.serial_decode.data_validate.preamble.25 _0203_ _0421_ sky130_fd_sc_hd__nand2_1
X169 data_multiplex.serial_decode.data_validate.preamble.24 _0202_ _0420_ sky130_fd_sc_hd__nand2_1
X170 _0092_ _0245_ _0418_ _0419_ sky130_fd_sc_hd__o21ai_0
X171 data_multiplex.serial_decode.data_validate.preamble.24 _0203_ _0419_ sky130_fd_sc_hd__nand2_1
X172 data_multiplex.serial_decode.data_validate.preamble.23 _0202_ _0418_ sky130_fd_sc_hd__nand2_1
X173 _0416_ _0417_ _0091_ sky130_fd_sc_hd__nand2_1
X174 data_multiplex.serial_decode.data_validate.preamble.23 _0203_ _0417_ sky130_fd_sc_hd__nand2_1
X175 data_multiplex.serial_decode.data_validate.preamble.22 _0202_ _0416_ sky130_fd_sc_hd__nand2_1
X176 _0090_ _0245_ _0414_ _0415_ sky130_fd_sc_hd__o21ai_0
X177 data_multiplex.serial_decode.data_validate.preamble.22 _0203_ _0415_ sky130_fd_sc_hd__nand2_1
X178 data_multiplex.serial_decode.data_validate.preamble.21 _0202_ _0414_ sky130_fd_sc_hd__nand2_1
X179 _0412_ _0413_ _0089_ sky130_fd_sc_hd__nand2_1
X180 data_multiplex.serial_decode.data_validate.preamble.21 _0203_ _0413_ sky130_fd_sc_hd__nand2_1
X181 data_multiplex.serial_decode.data_validate.preamble.20 _0202_ _0412_ sky130_fd_sc_hd__nand2_1
X182 _0088_ _0245_ _0410_ _0411_ sky130_fd_sc_hd__o21ai_0
X183 data_multiplex.serial_decode.data_validate.preamble.20 _0203_ _0411_ sky130_fd_sc_hd__nand2_1
X184 data_multiplex.serial_decode.data_validate.preamble.19 _0202_ _0410_ sky130_fd_sc_hd__nand2_1
X185 _0408_ _0409_ _0087_ sky130_fd_sc_hd__nand2_1
X186 data_multiplex.serial_decode.data_validate.preamble.19 _0203_ _0409_ sky130_fd_sc_hd__nand2_1
X187 data_multiplex.serial_decode.data_validate.preamble.18 _0202_ _0408_ sky130_fd_sc_hd__nand2_1
X188 _0086_ _0245_ _0406_ _0407_ sky130_fd_sc_hd__o21ai_0
X189 data_multiplex.serial_decode.data_validate.preamble.18 _0203_ _0407_ sky130_fd_sc_hd__nand2_1
X190 data_multiplex.serial_decode.data_validate.preamble.17 _0202_ _0406_ sky130_fd_sc_hd__nand2_1
X191 _0404_ _0405_ _0085_ sky130_fd_sc_hd__nand2_1
X192 data_multiplex.serial_decode.data_validate.preamble.17 _0203_ _0405_ sky130_fd_sc_hd__nand2_1
X193 data_multiplex.serial_decode.data_validate.preamble.16 _0202_ _0404_ sky130_fd_sc_hd__nand2_1
X194 _0084_ _0245_ _0402_ _0403_ sky130_fd_sc_hd__o21ai_0
X195 data_multiplex.serial_decode.data_validate.preamble.16 _0203_ _0403_ sky130_fd_sc_hd__nand2_1
X196 data_multiplex.serial_decode.data_validate.preamble.15 _0202_ _0402_ sky130_fd_sc_hd__nand2_1
X197 _0400_ _0401_ _0083_ sky130_fd_sc_hd__nand2_1
X198 data_multiplex.serial_decode.data_validate.preamble.15 _0203_ _0401_ sky130_fd_sc_hd__nand2_1
X199 data_multiplex.serial_decode.data_validate.preamble.14 _0202_ _0400_ sky130_fd_sc_hd__nand2_1
X200 _0082_ _0245_ _0398_ _0399_ sky130_fd_sc_hd__o21ai_0
X201 data_multiplex.serial_decode.data_validate.preamble.14 _0203_ _0399_ sky130_fd_sc_hd__nand2_1
X202 data_multiplex.serial_decode.data_validate.preamble.13 _0202_ _0398_ sky130_fd_sc_hd__nand2_1
X203 _0396_ _0397_ _0081_ sky130_fd_sc_hd__nand2_1
X204 data_multiplex.serial_decode.data_validate.preamble.13 _0203_ _0397_ sky130_fd_sc_hd__nand2_1
X205 data_multiplex.serial_decode.data_validate.preamble.12 _0202_ _0396_ sky130_fd_sc_hd__nand2_1
X206 _0080_ _0245_ _0394_ _0395_ sky130_fd_sc_hd__o21ai_0
X207 data_multiplex.serial_decode.data_validate.preamble.12 _0203_ _0395_ sky130_fd_sc_hd__nand2_1
X208 data_multiplex.serial_decode.data_validate.preamble.11 _0202_ _0394_ sky130_fd_sc_hd__nand2_1
X209 _0392_ _0393_ _0079_ sky130_fd_sc_hd__nand2_1
X210 data_multiplex.serial_decode.data_validate.preamble.11 _0203_ _0393_ sky130_fd_sc_hd__nand2_1
X211 data_multiplex.serial_decode.data_validate.preamble.10 _0202_ _0392_ sky130_fd_sc_hd__nand2_1
X212 _0078_ _0245_ _0390_ _0391_ sky130_fd_sc_hd__o21ai_0
X213 data_multiplex.serial_decode.data_validate.preamble.10 _0203_ _0391_ sky130_fd_sc_hd__nand2_1
X214 data_multiplex.serial_decode.data_validate.preamble.9 _0202_ _0390_ sky130_fd_sc_hd__nand2_1
X215 _0388_ _0389_ _0077_ sky130_fd_sc_hd__nand2_1
X216 data_multiplex.serial_decode.data_validate.preamble.9 _0203_ _0389_ sky130_fd_sc_hd__nand2_1
X217 data_multiplex.serial_decode.data_validate.preamble.8 _0202_ _0388_ sky130_fd_sc_hd__nand2_1
X218 _0076_ _0245_ _0386_ _0387_ sky130_fd_sc_hd__o21ai_0
X219 data_multiplex.serial_decode.data_validate.preamble.8 _0203_ _0387_ sky130_fd_sc_hd__nand2_1
X220 data_multiplex.serial_decode.data_validate.preamble.7 _0202_ _0386_ sky130_fd_sc_hd__nand2_1
X221 _0384_ _0385_ _0075_ sky130_fd_sc_hd__nand2_1
X222 data_multiplex.serial_decode.data_validate.preamble.7 _0203_ _0385_ sky130_fd_sc_hd__nand2_1
X223 data_multiplex.serial_decode.data_validate.preamble.6 _0202_ _0384_ sky130_fd_sc_hd__nand2_1
X224 _0074_ _0245_ _0382_ _0383_ sky130_fd_sc_hd__o21ai_0
X225 data_multiplex.serial_decode.data_validate.preamble.6 _0203_ _0383_ sky130_fd_sc_hd__nand2_1
X226 data_multiplex.serial_decode.data_validate.preamble.5 _0202_ _0382_ sky130_fd_sc_hd__nand2_1
X227 _0380_ _0381_ _0073_ sky130_fd_sc_hd__nand2_1
X228 data_multiplex.serial_decode.data_validate.preamble.5 _0203_ _0381_ sky130_fd_sc_hd__nand2_1
X229 data_multiplex.serial_decode.data_validate.preamble.4 _0202_ _0380_ sky130_fd_sc_hd__nand2_1
X230 _0072_ _0245_ _0378_ _0379_ sky130_fd_sc_hd__o21ai_0
X231 data_multiplex.serial_decode.data_validate.preamble.4 _0203_ _0379_ sky130_fd_sc_hd__nand2_1
X232 data_multiplex.serial_decode.data_validate.preamble.3 _0202_ _0378_ sky130_fd_sc_hd__nand2_1
X233 _0376_ _0377_ _0071_ sky130_fd_sc_hd__nand2_1
X234 data_multiplex.serial_decode.data_validate.preamble.3 _0203_ _0377_ sky130_fd_sc_hd__nand2_1
X235 data_multiplex.serial_decode.data_validate.preamble.2 _0202_ _0376_ sky130_fd_sc_hd__nand2_1
X236 _0070_ _0245_ _0374_ _0375_ sky130_fd_sc_hd__o21ai_0
X237 data_multiplex.serial_decode.data_validate.preamble.2 _0203_ _0375_ sky130_fd_sc_hd__nand2_1
X238 data_multiplex.serial_decode.data_validate.preamble.1 _0202_ _0374_ sky130_fd_sc_hd__nand2_1
X239 _0372_ _0373_ _0069_ sky130_fd_sc_hd__nand2_1
X240 data_multiplex.serial_decode.data_validate.preamble.1 _0203_ _0373_ sky130_fd_sc_hd__nand2_1
X241 data_multiplex.serial_decode.data_validate.preamble.0 _0202_ _0372_ sky130_fd_sc_hd__nand2_1
X242 _0068_ _0245_ _0370_ _0371_ sky130_fd_sc_hd__o21ai_0
X243 data_multiplex.serial_decode.data_validate.preamble.0 _0203_ _0371_ sky130_fd_sc_hd__nand2_1
X244 data_multiplex.room_temp.15 _0202_ _0370_ sky130_fd_sc_hd__nand2_1
X245 _0067_ _0245_ _0368_ _0369_ sky130_fd_sc_hd__o21ai_0
X246 data_multiplex.room_temp.15 _0203_ _0369_ sky130_fd_sc_hd__nand2_1
X247 data_multiplex.room_temp.14 _0202_ _0368_ sky130_fd_sc_hd__nand2_1
X248 _0366_ _0367_ _0066_ sky130_fd_sc_hd__nand2_1
X249 data_multiplex.room_temp.14 _0203_ _0367_ sky130_fd_sc_hd__nand2_1
X250 data_multiplex.room_temp.13 _0202_ _0366_ sky130_fd_sc_hd__nand2_1
X251 _0065_ _0245_ _0364_ _0365_ sky130_fd_sc_hd__o21ai_0
X252 data_multiplex.room_temp.13 _0203_ _0365_ sky130_fd_sc_hd__nand2_1
X253 data_multiplex.room_temp.12 _0202_ _0364_ sky130_fd_sc_hd__nand2_1
X254 _0362_ _0363_ _0064_ sky130_fd_sc_hd__nand2_1
X255 data_multiplex.room_temp.12 _0203_ _0363_ sky130_fd_sc_hd__nand2_1
X256 data_multiplex.room_temp.11 _0202_ _0362_ sky130_fd_sc_hd__nand2_1
X257 _0360_ _0361_ _0063_ sky130_fd_sc_hd__nand2_1
X258 data_multiplex.room_temp.11 _0203_ _0361_ sky130_fd_sc_hd__nand2_1
X259 data_multiplex.room_temp.10 _0202_ _0360_ sky130_fd_sc_hd__nand2_1
X260 _0062_ _0245_ _0358_ _0359_ sky130_fd_sc_hd__o21ai_0
X261 data_multiplex.room_temp.10 _0203_ _0359_ sky130_fd_sc_hd__nand2_1
X262 data_multiplex.room_temp.9 _0202_ _0358_ sky130_fd_sc_hd__nand2_1
X263 _0061_ _0245_ _0356_ _0357_ sky130_fd_sc_hd__o21ai_0
X264 data_multiplex.room_temp.9 _0203_ _0357_ sky130_fd_sc_hd__nand2_1
X265 data_multiplex.room_temp.8 _0202_ _0356_ sky130_fd_sc_hd__nand2_1
X266 _0060_ _0245_ _0354_ _0355_ sky130_fd_sc_hd__o21ai_0
X267 data_multiplex.room_temp.8 _0203_ _0355_ sky130_fd_sc_hd__nand2_1
X268 data_multiplex.room_temp.7 _0202_ _0354_ sky130_fd_sc_hd__nand2_1
X269 _0352_ _0353_ _0059_ sky130_fd_sc_hd__nand2_1
X270 data_multiplex.room_temp.7 _0203_ _0353_ sky130_fd_sc_hd__nand2_1
X271 data_multiplex.room_temp.6 _0202_ _0352_ sky130_fd_sc_hd__nand2_1
X272 _0350_ _0351_ _0058_ sky130_fd_sc_hd__nand2_1
X273 data_multiplex.room_temp.6 _0203_ _0351_ sky130_fd_sc_hd__nand2_1
X274 data_multiplex.room_temp.5 _0202_ _0350_ sky130_fd_sc_hd__nand2_1
X275 _0057_ _0245_ _0348_ _0349_ sky130_fd_sc_hd__o21ai_0
X276 data_multiplex.room_temp.5 _0203_ _0349_ sky130_fd_sc_hd__nand2_1
X277 data_multiplex.room_temp.4 _0202_ _0348_ sky130_fd_sc_hd__nand2_1
X278 _0346_ _0347_ _0056_ sky130_fd_sc_hd__nand2_1
X279 data_multiplex.room_temp.4 _0203_ _0347_ sky130_fd_sc_hd__nand2_1
X280 data_multiplex.room_temp.3 _0202_ _0346_ sky130_fd_sc_hd__nand2_1
X281 _0344_ _0345_ _0055_ sky130_fd_sc_hd__nand2_1
X282 data_multiplex.room_temp.3 _0203_ _0345_ sky130_fd_sc_hd__nand2_1
X283 data_multiplex.room_temp.2 _0202_ _0344_ sky130_fd_sc_hd__nand2_1
X284 _0342_ _0343_ _0054_ sky130_fd_sc_hd__nand2_1
X285 data_multiplex.room_temp.2 _0203_ _0343_ sky130_fd_sc_hd__nand2_1
X286 data_multiplex.room_temp.1 _0202_ _0342_ sky130_fd_sc_hd__nand2_1
X287 _0053_ _0245_ _0340_ _0341_ sky130_fd_sc_hd__o21ai_0
X288 data_multiplex.room_temp.1 _0203_ _0341_ sky130_fd_sc_hd__nand2_1
X289 data_multiplex.room_temp.0 _0202_ _0340_ sky130_fd_sc_hd__nand2_1
X290 _0052_ _0245_ _0338_ _0339_ sky130_fd_sc_hd__o21ai_0
X291 data_multiplex.room_temp.0 _0203_ _0339_ sky130_fd_sc_hd__nand2_1
X292 data_multiplex.serial_decode.data_validate.type_2.15 _0202_ _0338_ sky130_fd_sc_hd__nand2_1
X293 _0051_ _0245_ _0336_ _0337_ sky130_fd_sc_hd__o21ai_0
X294 data_multiplex.serial_decode.data_validate.type_2.15 _0203_ _0337_ sky130_fd_sc_hd__nand2_1
X295 data_multiplex.serial_decode.data_validate.type_2.14 _0202_ _0336_ sky130_fd_sc_hd__nand2_1
X296 _0334_ _0335_ _0050_ sky130_fd_sc_hd__nand2_1
X297 data_multiplex.serial_decode.data_validate.type_2.14 _0203_ _0335_ sky130_fd_sc_hd__nand2_1
X298 data_multiplex.serial_decode.data_validate.type_2.13 _0202_ _0334_ sky130_fd_sc_hd__nand2_1
X299 _0049_ _0245_ _0332_ _0333_ sky130_fd_sc_hd__o21ai_0
X300 data_multiplex.serial_decode.data_validate.type_2.13 _0203_ _0333_ sky130_fd_sc_hd__nand2_1
X301 data_multiplex.serial_decode.data_validate.type_2.12 _0202_ _0332_ sky130_fd_sc_hd__nand2_1
X302 _0330_ _0331_ _0048_ sky130_fd_sc_hd__nand2_1
X303 data_multiplex.serial_decode.data_validate.type_2.12 _0203_ _0331_ sky130_fd_sc_hd__nand2_1
X304 data_multiplex.serial_decode.data_validate.type_2.11 _0202_ _0330_ sky130_fd_sc_hd__nand2_1
X305 _0328_ _0329_ _0047_ sky130_fd_sc_hd__nand2_1
X306 data_multiplex.serial_decode.data_validate.type_2.11 _0203_ _0329_ sky130_fd_sc_hd__nand2_1
X307 data_multiplex.serial_decode.data_validate.type_2.10 _0202_ _0328_ sky130_fd_sc_hd__nand2_1
X308 _0046_ _0245_ _0326_ _0327_ sky130_fd_sc_hd__o21ai_0
X309 data_multiplex.serial_decode.data_validate.type_2.10 _0203_ _0327_ sky130_fd_sc_hd__nand2_1
X310 data_multiplex.serial_decode.data_validate.type_2.9 _0202_ _0326_ sky130_fd_sc_hd__nand2_1
X311 _0045_ _0245_ _0324_ _0325_ sky130_fd_sc_hd__o21ai_0
X312 data_multiplex.serial_decode.data_validate.type_2.9 _0203_ _0325_ sky130_fd_sc_hd__nand2_1
X313 data_multiplex.serial_decode.data_validate.type_2.8 _0202_ _0324_ sky130_fd_sc_hd__nand2_1
X314 _0044_ _0245_ _0322_ _0323_ sky130_fd_sc_hd__o21ai_0
X315 data_multiplex.serial_decode.data_validate.type_2.8 _0203_ _0323_ sky130_fd_sc_hd__nand2_1
X316 data_multiplex.serial_decode.data_validate.type_2.7 _0202_ _0322_ sky130_fd_sc_hd__nand2_1
X317 _0320_ _0321_ _0043_ sky130_fd_sc_hd__nand2_1
X318 data_multiplex.serial_decode.data_validate.type_2.7 _0203_ _0321_ sky130_fd_sc_hd__nand2_1
X319 data_multiplex.serial_decode.data_validate.type_2.6 _0202_ _0320_ sky130_fd_sc_hd__nand2_1
X320 _0318_ _0319_ _0042_ sky130_fd_sc_hd__nand2_1
X321 data_multiplex.serial_decode.data_validate.type_2.6 _0203_ _0319_ sky130_fd_sc_hd__nand2_1
X322 data_multiplex.serial_decode.data_validate.type_2.5 _0202_ _0318_ sky130_fd_sc_hd__nand2_1
X323 _0041_ _0245_ _0316_ _0317_ sky130_fd_sc_hd__o21ai_0
X324 data_multiplex.serial_decode.data_validate.type_2.5 _0203_ _0317_ sky130_fd_sc_hd__nand2_1
X325 data_multiplex.serial_decode.data_validate.type_2.4 _0202_ _0316_ sky130_fd_sc_hd__nand2_1
X326 _0314_ _0315_ _0040_ sky130_fd_sc_hd__nand2_1
X327 data_multiplex.serial_decode.data_validate.type_2.4 _0203_ _0315_ sky130_fd_sc_hd__nand2_1
X328 data_multiplex.serial_decode.data_validate.type_2.3 _0202_ _0314_ sky130_fd_sc_hd__nand2_1
X329 _0312_ _0313_ _0039_ sky130_fd_sc_hd__nand2_1
X330 data_multiplex.serial_decode.data_validate.type_2.3 _0203_ _0313_ sky130_fd_sc_hd__nand2_1
X331 data_multiplex.serial_decode.data_validate.type_2.2 _0202_ _0312_ sky130_fd_sc_hd__nand2_1
X332 _0310_ _0311_ _0038_ sky130_fd_sc_hd__nand2_1
X333 data_multiplex.serial_decode.data_validate.type_2.2 _0203_ _0311_ sky130_fd_sc_hd__nand2_1
X334 data_multiplex.serial_decode.data_validate.type_2.1 _0202_ _0310_ sky130_fd_sc_hd__nand2_1
X335 _0037_ _0245_ _0308_ _0309_ sky130_fd_sc_hd__o21ai_0
X336 data_multiplex.serial_decode.data_validate.type_2.1 _0203_ _0309_ sky130_fd_sc_hd__nand2_1
X337 data_multiplex.serial_decode.data_validate.type_2.0 _0202_ _0308_ sky130_fd_sc_hd__nand2_1
X338 _0306_ _0307_ _0036_ sky130_fd_sc_hd__nand2_1
X339 data_multiplex.serial_decode.data_validate.type_2.0 _0203_ _0307_ sky130_fd_sc_hd__nand2_1
X340 data_multiplex.serial_decode.constant.31 _0202_ _0306_ sky130_fd_sc_hd__nand2_1
X341 _0304_ _0305_ _0035_ sky130_fd_sc_hd__nand2_1
X342 data_multiplex.serial_decode.constant.31 _0203_ _0305_ sky130_fd_sc_hd__nand2_1
X343 data_multiplex.serial_decode.constant.30 _0202_ _0304_ sky130_fd_sc_hd__nand2_1
X344 _0302_ _0303_ _0034_ sky130_fd_sc_hd__nand2_1
X345 data_multiplex.serial_decode.constant.30 _0203_ _0303_ sky130_fd_sc_hd__nand2_1
X346 data_multiplex.serial_decode.constant.29 _0202_ _0302_ sky130_fd_sc_hd__nand2_1
X347 _0300_ _0301_ _0033_ sky130_fd_sc_hd__nand2_1
X348 data_multiplex.serial_decode.constant.29 _0203_ _0301_ sky130_fd_sc_hd__nand2_1
X349 data_multiplex.serial_decode.constant.28 _0202_ _0300_ sky130_fd_sc_hd__nand2_1
X350 _0032_ _0245_ _0298_ _0299_ sky130_fd_sc_hd__o21ai_0
X351 data_multiplex.serial_decode.constant.28 _0203_ _0299_ sky130_fd_sc_hd__nand2_1
X352 data_multiplex.serial_decode.constant.27 _0202_ _0298_ sky130_fd_sc_hd__nand2_1
X353 _0031_ _0245_ _0296_ _0297_ sky130_fd_sc_hd__o21ai_0
X354 data_multiplex.serial_decode.constant.27 _0203_ _0297_ sky130_fd_sc_hd__nand2_1
X355 data_multiplex.serial_decode.constant.26 _0202_ _0296_ sky130_fd_sc_hd__nand2_1
X356 _0294_ _0295_ _0030_ sky130_fd_sc_hd__nand2_1
X357 data_multiplex.serial_decode.constant.26 _0203_ _0295_ sky130_fd_sc_hd__nand2_1
X358 data_multiplex.serial_decode.constant.25 _0202_ _0294_ sky130_fd_sc_hd__nand2_1
X359 _0029_ _0245_ _0292_ _0293_ sky130_fd_sc_hd__o21ai_0
X360 data_multiplex.serial_decode.constant.25 _0203_ _0293_ sky130_fd_sc_hd__nand2_1
X361 data_multiplex.serial_decode.constant.24 _0202_ _0292_ sky130_fd_sc_hd__nand2_1
X362 _0028_ _0245_ _0290_ _0291_ sky130_fd_sc_hd__o21ai_0
X363 data_multiplex.serial_decode.constant.24 _0203_ _0291_ sky130_fd_sc_hd__nand2_1
X364 data_multiplex.serial_decode.constant.23 _0202_ _0290_ sky130_fd_sc_hd__nand2_1
X365 _0027_ _0245_ _0288_ _0289_ sky130_fd_sc_hd__o21ai_0
X366 data_multiplex.serial_decode.constant.23 _0203_ _0289_ sky130_fd_sc_hd__nand2_1
X367 data_multiplex.serial_decode.constant.22 _0202_ _0288_ sky130_fd_sc_hd__nand2_1
X368 _0026_ _0245_ _0286_ _0287_ sky130_fd_sc_hd__o21ai_0
X369 data_multiplex.serial_decode.constant.22 _0203_ _0287_ sky130_fd_sc_hd__nand2_1
X370 data_multiplex.serial_decode.constant.21 _0202_ _0286_ sky130_fd_sc_hd__nand2_1
X371 _0025_ _0245_ _0284_ _0285_ sky130_fd_sc_hd__o21ai_0
X372 data_multiplex.serial_decode.constant.21 _0203_ _0285_ sky130_fd_sc_hd__nand2_1
X373 data_multiplex.serial_decode.constant.20 _0202_ _0284_ sky130_fd_sc_hd__nand2_1
X374 _0024_ _0245_ _0282_ _0283_ sky130_fd_sc_hd__o21ai_0
X375 data_multiplex.serial_decode.constant.20 _0203_ _0283_ sky130_fd_sc_hd__nand2_1
X376 data_multiplex.serial_decode.constant.19 _0202_ _0282_ sky130_fd_sc_hd__nand2_1
X377 _0023_ _0245_ _0280_ _0281_ sky130_fd_sc_hd__o21ai_0
X378 data_multiplex.serial_decode.constant.19 _0203_ _0281_ sky130_fd_sc_hd__nand2_1
X379 data_multiplex.serial_decode.constant.18 _0202_ _0280_ sky130_fd_sc_hd__nand2_1
X380 _0022_ _0245_ _0278_ _0279_ sky130_fd_sc_hd__o21ai_0
X381 data_multiplex.serial_decode.constant.18 _0203_ _0279_ sky130_fd_sc_hd__nand2_1
X382 data_multiplex.serial_decode.constant.17 _0202_ _0278_ sky130_fd_sc_hd__nand2_1
X383 _0021_ _0245_ _0276_ _0277_ sky130_fd_sc_hd__o21ai_0
X384 data_multiplex.serial_decode.constant.17 _0203_ _0277_ sky130_fd_sc_hd__nand2_1
X385 data_multiplex.serial_decode.constant.16 _0202_ _0276_ sky130_fd_sc_hd__nand2_1
X386 _0020_ _0245_ _0274_ _0275_ sky130_fd_sc_hd__o21ai_0
X387 data_multiplex.serial_decode.constant.16 _0203_ _0275_ sky130_fd_sc_hd__nand2_1
X388 data_multiplex.serial_decode.constant.15 _0202_ _0274_ sky130_fd_sc_hd__nand2_1
X389 _0019_ _0245_ _0272_ _0273_ sky130_fd_sc_hd__o21ai_0
X390 data_multiplex.serial_decode.constant.15 _0203_ _0273_ sky130_fd_sc_hd__nand2_1
X391 data_multiplex.serial_decode.constant.14 _0202_ _0272_ sky130_fd_sc_hd__nand2_1
X392 _0018_ _0245_ _0270_ _0271_ sky130_fd_sc_hd__o21ai_0
X393 data_multiplex.serial_decode.constant.14 _0203_ _0271_ sky130_fd_sc_hd__nand2_1
X394 data_multiplex.serial_decode.constant.13 _0202_ _0270_ sky130_fd_sc_hd__nand2_1
X395 _0017_ _0245_ _0268_ _0269_ sky130_fd_sc_hd__o21ai_0
X396 data_multiplex.serial_decode.constant.13 _0203_ _0269_ sky130_fd_sc_hd__nand2_1
X397 data_multiplex.serial_decode.constant.12 _0202_ _0268_ sky130_fd_sc_hd__nand2_1
X398 _0016_ _0245_ _0266_ _0267_ sky130_fd_sc_hd__o21ai_0
X399 data_multiplex.serial_decode.constant.12 _0203_ _0267_ sky130_fd_sc_hd__nand2_1
X400 data_multiplex.serial_decode.constant.11 _0202_ _0266_ sky130_fd_sc_hd__nand2_1
X401 _0015_ _0245_ _0264_ _0265_ sky130_fd_sc_hd__o21ai_0
X402 data_multiplex.serial_decode.constant.11 _0203_ _0265_ sky130_fd_sc_hd__nand2_1
X403 data_multiplex.serial_decode.constant.10 _0202_ _0264_ sky130_fd_sc_hd__nand2_1
X404 _0014_ _0245_ _0262_ _0263_ sky130_fd_sc_hd__o21ai_0
X405 data_multiplex.serial_decode.constant.10 _0203_ _0263_ sky130_fd_sc_hd__nand2_1
X406 data_multiplex.serial_decode.constant.9 _0202_ _0262_ sky130_fd_sc_hd__nand2_1
X407 _0013_ _0245_ _0260_ _0261_ sky130_fd_sc_hd__o21ai_0
X408 data_multiplex.serial_decode.constant.9 _0203_ _0261_ sky130_fd_sc_hd__nand2_1
X409 data_multiplex.serial_decode.constant.8 _0202_ _0260_ sky130_fd_sc_hd__nand2_1
X410 _0012_ _0245_ _0258_ _0259_ sky130_fd_sc_hd__o21ai_0
X411 data_multiplex.serial_decode.constant.8 _0203_ _0259_ sky130_fd_sc_hd__nand2_1
X412 data_multiplex.serial_decode.constant.7 _0202_ _0258_ sky130_fd_sc_hd__nand2_1
X413 _0011_ _0245_ _0256_ _0257_ sky130_fd_sc_hd__o21ai_0
X414 data_multiplex.serial_decode.constant.7 _0203_ _0257_ sky130_fd_sc_hd__nand2_1
X415 data_multiplex.serial_decode.constant.6 _0202_ _0256_ sky130_fd_sc_hd__nand2_1
X416 _0010_ _0245_ _0254_ _0255_ sky130_fd_sc_hd__o21ai_0
X417 data_multiplex.serial_decode.constant.6 _0203_ _0255_ sky130_fd_sc_hd__nand2_1
X418 data_multiplex.serial_decode.constant.5 _0202_ _0254_ sky130_fd_sc_hd__nand2_1
X419 _0009_ _0245_ _0252_ _0253_ sky130_fd_sc_hd__o21ai_0
X420 data_multiplex.serial_decode.constant.5 _0203_ _0253_ sky130_fd_sc_hd__nand2_1
X421 data_multiplex.serial_decode.constant.4 _0202_ _0252_ sky130_fd_sc_hd__nand2_1
X422 _0008_ _0245_ _0250_ _0251_ sky130_fd_sc_hd__o21ai_0
X423 data_multiplex.serial_decode.constant.4 _0203_ _0251_ sky130_fd_sc_hd__nand2_1
X424 data_multiplex.serial_decode.constant.3 _0202_ _0250_ sky130_fd_sc_hd__nand2_1
X425 _0007_ _0245_ _0248_ _0249_ sky130_fd_sc_hd__o21ai_0
X426 data_multiplex.serial_decode.constant.3 _0203_ _0249_ sky130_fd_sc_hd__nand2_1
X427 data_multiplex.serial_decode.constant.2 _0202_ _0248_ sky130_fd_sc_hd__nand2_1
X428 _0006_ _0245_ _0246_ _0247_ sky130_fd_sc_hd__o21ai_0
X429 data_multiplex.serial_decode.constant.2 _0203_ _0247_ sky130_fd_sc_hd__nand2_1
X430 data_multiplex.serial_decode.constant.1 _0202_ _0246_ sky130_fd_sc_hd__nand2_1
X431 _0005_ data_multiplex.serial_decode.constant.1 _0202_ _0206_ _0245_ sky130_fd_sc_hd__o22a_1
X432 _0211_ _0220_ _0226_ _0244_ _0245_ sky130_fd_sc_hd__nor4_1
X433 _0228_ _0233_ _0238_ _0243_ _0244_ sky130_fd_sc_hd__nand4_1
X434 _0239_ _0240_ _0241_ _0242_ _0243_ sky130_fd_sc_hd__nor4_1
X435 data_multiplex.serial_decode.data_validate.type_2.3 data_multiplex.serial_decode.data_validate.type_2.2 data_multiplex.serial_decode.data_validate.type_2.5 _0242_ data_multiplex.serial_decode.data_validate.type_2.0 sky130_fd_sc_hd__or4b_1
X436 data_multiplex.serial_decode.constant.28 data_multiplex.serial_decode.constant.31 data_multiplex.serial_decode.constant.30 data_multiplex.serial_decode.data_validate.type_2.1 _0241_ sky130_fd_sc_hd__or4_1
X437 data_multiplex.serial_decode.constant.22 data_multiplex.serial_decode.constant.23 data_multiplex.serial_decode.constant.20 _0240_ data_multiplex.serial_decode.constant.25 sky130_fd_sc_hd__nand4b_1
X438 data_multiplex.serial_decode.constant.26 data_multiplex.serial_decode.constant.27 data_multiplex.serial_decode.constant.24 _0239_ data_multiplex.serial_decode.constant.29 sky130_fd_sc_hd__nand4b_1
X439 _0234_ _0235_ _0236_ _0237_ _0238_ sky130_fd_sc_hd__nor4_1
X440 data_multiplex.serial_decode.data_validate.type_2.14 data_multiplex.serial_decode.data_validate.type_2.15 data_multiplex.serial_decode.data_validate.type_2.12 _0237_ data_multiplex.room_temp.1 sky130_fd_sc_hd__nand4b_1
X441 data_multiplex.room_temp.3 data_multiplex.room_temp.2 data_multiplex.room_temp.5 _0236_ data_multiplex.room_temp.0 sky130_fd_sc_hd__or4b_1
X442 data_multiplex.serial_decode.data_validate.type_2.11 data_multiplex.serial_decode.data_validate.type_2.10 data_multiplex.serial_decode.data_validate.type_2.13 _0235_ data_multiplex.serial_decode.data_validate.type_2.8 sky130_fd_sc_hd__or4b_1
X443 data_multiplex.serial_decode.data_validate.type_2.7 data_multiplex.serial_decode.data_validate.type_2.9 data_multiplex.serial_decode.data_validate.type_2.4 _0234_ data_multiplex.serial_decode.data_validate.type_2.6 sky130_fd_sc_hd__nand4b_1
X444 _0229_ _0230_ _0231_ _0232_ _0233_ sky130_fd_sc_hd__nor4_1
X445 data_multiplex.serial_decode.constant.12 data_multiplex.serial_decode.constant.15 data_multiplex.serial_decode.constant.14 data_multiplex.serial_decode.constant.17 _0232_ sky130_fd_sc_hd__nand4_1
X446 data_multiplex.serial_decode.constant.16 data_multiplex.serial_decode.constant.19 data_multiplex.serial_decode.constant.18 data_multiplex.serial_decode.constant.21 _0231_ sky130_fd_sc_hd__nand4_1
X447 data_multiplex.serial_decode.constant.5 data_multiplex.serial_decode.constant.7 data_multiplex.serial_decode.constant.6 data_multiplex.serial_decode.constant.9 _0230_ sky130_fd_sc_hd__nand4_1
X448 data_multiplex.serial_decode.constant.8 data_multiplex.serial_decode.constant.11 data_multiplex.serial_decode.constant.10 data_multiplex.serial_decode.constant.13 _0229_ sky130_fd_sc_hd__nand4_1
X449 data_multiplex.serial_decode.preamble_or_data data_multiplex.serial_decode.constant.0 _0227_ _0228_ sky130_fd_sc_hd__nor3_1
X450 data_multiplex.serial_decode.constant.1 data_multiplex.serial_decode.constant.2 data_multiplex.serial_decode.constant.3 data_multiplex.serial_decode.constant.4 _0227_ sky130_fd_sc_hd__nand4_1
X451 _0221_ _0222_ _0225_ _0226_ sky130_fd_sc_hd__nand3_1
X452 data_multiplex.serial_decode.data_validate.preamble.2 data_multiplex.serial_decode.data_validate.preamble.4 _0223_ _0224_ _0225_ sky130_fd_sc_hd__nor4_1
X453 data_multiplex.room_temp.14 data_multiplex.room_temp.15 data_multiplex.room_temp.12 _0224_ data_multiplex.serial_decode.data_validate.preamble.0 sky130_fd_sc_hd__nand4b_1
X454 data_multiplex.serial_decode.data_validate.preamble.1 data_multiplex.serial_decode.data_validate.preamble.3 _0223_ sky130_fd_sc_hd__nand2_1
X455 data_multiplex.room_temp.11 data_multiplex.room_temp.10 data_multiplex.room_temp.13 _0222_ data_multiplex.room_temp.8 sky130_fd_sc_hd__nor4b_1
X456 data_multiplex.room_temp.7 data_multiplex.room_temp.9 data_multiplex.room_temp.4 _0221_ data_multiplex.room_temp.6 sky130_fd_sc_hd__and4b_1
X457 _0213_ _0215_ _0217_ _0219_ _0220_ sky130_fd_sc_hd__nand4_1
X458 data_multiplex.serial_decode.data_validate.preamble.18 data_multiplex.serial_decode.data_validate.preamble.20 _0218_ _0219_ sky130_fd_sc_hd__nor3_1
X459 data_multiplex.serial_decode.data_validate.preamble.17 data_multiplex.serial_decode.data_validate.preamble.19 _0218_ sky130_fd_sc_hd__nand2_1
X460 data_multiplex.serial_decode.data_validate.preamble.14 data_multiplex.serial_decode.data_validate.preamble.16 _0216_ _0217_ sky130_fd_sc_hd__nor3_1
X461 data_multiplex.serial_decode.data_validate.preamble.13 data_multiplex.serial_decode.data_validate.preamble.15 _0216_ sky130_fd_sc_hd__nand2_1
X462 data_multiplex.serial_decode.data_validate.preamble.6 data_multiplex.serial_decode.data_validate.preamble.8 _0214_ _0215_ sky130_fd_sc_hd__nor3_1
X463 data_multiplex.serial_decode.data_validate.preamble.5 data_multiplex.serial_decode.data_validate.preamble.7 _0214_ sky130_fd_sc_hd__nand2_1
X464 data_multiplex.serial_decode.data_validate.preamble.10 data_multiplex.serial_decode.data_validate.preamble.12 _0212_ _0213_ sky130_fd_sc_hd__nor3_1
X465 data_multiplex.serial_decode.data_validate.preamble.9 data_multiplex.serial_decode.data_validate.preamble.11 _0212_ sky130_fd_sc_hd__nand2_1
X466 data_multiplex.serial_decode.data_validate.preamble.30 _0207_ _0210_ _0211_ sky130_fd_sc_hd__or3_1
X467 data_multiplex.serial_decode.data_validate.preamble.25 data_multiplex.serial_decode.data_validate.preamble.27 _0208_ _0209_ _0210_ sky130_fd_sc_hd__nand4_1
X468 data_multiplex.serial_decode.data_validate.preamble.22 data_multiplex.serial_decode.data_validate.preamble.24 _0209_ data_multiplex.serial_decode.data_validate.preamble.23 data_multiplex.serial_decode.data_validate.preamble.21 sky130_fd_sc_hd__nor4bb_1
X469 data_multiplex.serial_decode.data_validate.preamble.26 data_multiplex.serial_decode.data_validate.preamble.28 _0208_ sky130_fd_sc_hd__nor2_1
X470 data_multiplex.serial_decode.data_validate.preamble.29 data_multiplex.serial_decode.data_validate.preamble.31 _0207_ sky130_fd_sc_hd__nand2_1
X471 data_multiplex.serial_decode.constant.0 _0206_ _0203_ sky130_fd_sc_hd__lpflow_inputiso1p_1
X472 _0204_ _0205_ _0004_ sky130_fd_sc_hd__nand2_1
X473 data_multiplex.serial_decode.constant.0 _0203_ _0205_ sky130_fd_sc_hd__nand2_1
X474 uio_out.2 _0202_ _0204_ sky130_fd_sc_hd__nand2_1
X475 uio_out.1 _0110_ _0203_ sky130_fd_sc_hd__nand2_1
X476 uio_out.1 _0110_ _0202_ sky130_fd_sc_hd__and2_0
X477 uo_out.7 _0198_ _0201_ ui_in.2 sky130_fd_sc_hd__o21a_1
X478 _0195_ _0199_ _0200_ _0201_ sky130_fd_sc_hd__nand3_1
X479 _0200_ data_multiplex.serial_decode.data_validate.type_2.7 _0140_ _0144_ _0141_ data_multiplex.room_temp.7 data_multiplex.serial_decode.constant.7 sky130_fd_sc_hd__a222oi_1
X480 _0199_ data_multiplex.serial_decode.constant.15 _0136_ _0143_ _0147_ data_multiplex.serial_decode.constant.23 data_multiplex.serial_decode.data_validate.type_2.15 sky130_fd_sc_hd__a222oi_1
X481 _0196_ _0197_ _0198_ sky130_fd_sc_hd__nand2_1
X482 _0197_ data_multiplex.serial_decode.data_validate.preamble.23 _0138_ _0148_ data_multiplex.room_temp.15 sky130_fd_sc_hd__a22oi_1
X483 _0196_ data_multiplex.serial_decode.data_validate.preamble.7 _0131_ _0146_ _0145_ data_multiplex.serial_decode.data_validate.preamble.15 data_multiplex.serial_decode.constant.31 sky130_fd_sc_hd__a222oi_1
X484 data_multiplex.serial_decode.data_validate.preamble.31 _0133_ _0195_ sky130_fd_sc_hd__nand2_1
X485 uo_out.6 _0190_ _0194_ ui_in.2 sky130_fd_sc_hd__o21a_1
X486 _0189_ _0191_ _0192_ _0193_ _0194_ sky130_fd_sc_hd__nand4_1
X487 _0193_ data_multiplex.serial_decode.constant.14 _0136_ _0143_ data_multiplex.serial_decode.data_validate.preamble.30 data_multiplex.serial_decode.constant.22 _0133_ sky130_fd_sc_hd__a222oi_1
X488 _0192_ data_multiplex.serial_decode.data_validate.preamble.22 _0138_ _0144_ data_multiplex.serial_decode.constant.30 data_multiplex.room_temp.6 _0145_ sky130_fd_sc_hd__a222oi_1
X489 _0191_ data_multiplex.serial_decode.data_validate.preamble.14 _0146_ _0148_ data_multiplex.room_temp.14 sky130_fd_sc_hd__a22oi_1
X490 _0190_ data_multiplex.serial_decode.data_validate.preamble.6 _0131_ _0147_ data_multiplex.serial_decode.data_validate.type_2.14 sky130_fd_sc_hd__a22o_1
X491 _0189_ data_multiplex.serial_decode.data_validate.type_2.6 _0140_ _0141_ data_multiplex.serial_decode.constant.6 sky130_fd_sc_hd__a22oi_1
X492 uo_out.5 _0184_ _0188_ ui_in.2 sky130_fd_sc_hd__o21a_1
X493 _0181_ _0185_ _0186_ _0187_ _0188_ sky130_fd_sc_hd__nand4_1
X494 _0187_ data_multiplex.serial_decode.constant.29 _0145_ _0146_ data_multiplex.serial_decode.data_validate.preamble.13 sky130_fd_sc_hd__a22oi_1
X495 _0186_ data_multiplex.serial_decode.data_validate.preamble.29 _0133_ _0148_ data_multiplex.room_temp.13 sky130_fd_sc_hd__a22oi_1
X496 _0185_ data_multiplex.serial_decode.data_validate.preamble.21 _0138_ _0144_ data_multiplex.serial_decode.data_validate.type_2.13 data_multiplex.room_temp.5 _0147_ sky130_fd_sc_hd__a222oi_1
X497 _0182_ _0183_ _0184_ sky130_fd_sc_hd__nand2_1
X498 _0183_ data_multiplex.serial_decode.data_validate.preamble.5 _0131_ _0140_ data_multiplex.serial_decode.constant.21 data_multiplex.serial_decode.data_validate.type_2.5 _0143_ sky130_fd_sc_hd__a222oi_1
X499 data_multiplex.serial_decode.constant.5 _0141_ _0182_ sky130_fd_sc_hd__nand2_1
X500 data_multiplex.serial_decode.constant.13 _0136_ _0181_ sky130_fd_sc_hd__nand2_1
X501 uo_out.4 _0177_ _0180_ ui_in.2 sky130_fd_sc_hd__o21a_1
X502 _0174_ _0178_ _0179_ _0180_ sky130_fd_sc_hd__nand3_1
X503 _0179_ data_multiplex.serial_decode.constant.12 _0136_ _0138_ _0140_ data_multiplex.serial_decode.data_validate.preamble.20 data_multiplex.serial_decode.data_validate.type_2.4 sky130_fd_sc_hd__a222oi_1
X504 _0178_ data_multiplex.serial_decode.constant.4 _0141_ _0146_ _0147_ data_multiplex.serial_decode.data_validate.preamble.12 data_multiplex.serial_decode.data_validate.type_2.12 sky130_fd_sc_hd__a222oi_1
X505 _0175_ _0176_ _0177_ sky130_fd_sc_hd__nand2_1
X506 _0176_ data_multiplex.room_temp.4 _0144_ _0148_ data_multiplex.room_temp.12 sky130_fd_sc_hd__a22oi_1
X507 _0175_ data_multiplex.serial_decode.data_validate.preamble.4 _0131_ _0133_ _0143_ data_multiplex.serial_decode.data_validate.preamble.28 data_multiplex.serial_decode.constant.20 sky130_fd_sc_hd__a222oi_1
X508 data_multiplex.serial_decode.constant.28 _0145_ _0174_ sky130_fd_sc_hd__nand2_1
X509 uo_out.3 _0169_ _0173_ ui_in.2 sky130_fd_sc_hd__o21a_1
X510 _0168_ _0170_ _0171_ _0172_ _0173_ sky130_fd_sc_hd__nand4_1
X511 _0172_ data_multiplex.serial_decode.constant.11 _0136_ _0140_ _0143_ data_multiplex.serial_decode.data_validate.type_2.3 data_multiplex.serial_decode.constant.19 sky130_fd_sc_hd__a222oi_1
X512 _0171_ data_multiplex.serial_decode.data_validate.preamble.27 _0133_ _0146_ data_multiplex.room_temp.11 data_multiplex.serial_decode.data_validate.preamble.11 _0148_ sky130_fd_sc_hd__a222oi_1
X513 _0170_ data_multiplex.serial_decode.constant.3 _0141_ _0147_ data_multiplex.serial_decode.data_validate.type_2.11 sky130_fd_sc_hd__a22oi_1
X514 _0169_ data_multiplex.serial_decode.data_validate.preamble.3 _0131_ _0138_ data_multiplex.serial_decode.data_validate.preamble.19 sky130_fd_sc_hd__a22o_1
X515 _0168_ data_multiplex.room_temp.3 _0144_ _0145_ data_multiplex.serial_decode.constant.27 sky130_fd_sc_hd__a22oi_1
X516 uo_out.2 _0164_ _0167_ ui_in.2 sky130_fd_sc_hd__o21a_1
X517 _0161_ _0165_ _0166_ _0167_ sky130_fd_sc_hd__nand3_1
X518 _0166_ data_multiplex.serial_decode.data_validate.preamble.18 _0138_ _0140_ data_multiplex.serial_decode.constant.2 data_multiplex.serial_decode.data_validate.type_2.2 _0141_ sky130_fd_sc_hd__a222oi_1
X519 _0165_ data_multiplex.serial_decode.constant.10 _0136_ _0143_ _0145_ data_multiplex.serial_decode.constant.18 data_multiplex.serial_decode.constant.26 sky130_fd_sc_hd__a222oi_1
X520 _0162_ _0163_ _0164_ sky130_fd_sc_hd__nand2_1
X521 _0163_ data_multiplex.room_temp.2 _0144_ _0148_ data_multiplex.room_temp.10 sky130_fd_sc_hd__a22oi_1
X522 _0162_ data_multiplex.serial_decode.data_validate.preamble.2 _0131_ _0146_ _0147_ data_multiplex.serial_decode.data_validate.preamble.10 data_multiplex.serial_decode.data_validate.type_2.10 sky130_fd_sc_hd__a222oi_1
X523 data_multiplex.serial_decode.data_validate.preamble.26 _0133_ _0161_ sky130_fd_sc_hd__nand2_1
X524 uo_out.1 _0156_ _0160_ ui_in.2 sky130_fd_sc_hd__o21a_1
X525 _0155_ _0157_ _0158_ _0159_ _0160_ sky130_fd_sc_hd__nand4_1
X526 _0159_ data_multiplex.serial_decode.constant.9 _0136_ _0143_ _0146_ data_multiplex.serial_decode.constant.17 data_multiplex.serial_decode.data_validate.preamble.9 sky130_fd_sc_hd__a222oi_1
X527 _0158_ data_multiplex.serial_decode.data_validate.preamble.17 _0138_ _0144_ data_multiplex.serial_decode.constant.25 data_multiplex.room_temp.1 _0145_ sky130_fd_sc_hd__a222oi_1
X528 _0157_ data_multiplex.serial_decode.data_validate.preamble.25 _0133_ _0148_ data_multiplex.room_temp.9 sky130_fd_sc_hd__a22oi_1
X529 _0156_ data_multiplex.serial_decode.data_validate.preamble.1 _0131_ _0147_ data_multiplex.serial_decode.data_validate.type_2.9 sky130_fd_sc_hd__a22o_1
X530 _0155_ data_multiplex.serial_decode.data_validate.type_2.1 _0140_ _0141_ data_multiplex.serial_decode.constant.1 sky130_fd_sc_hd__a22oi_1
X531 uo_out.0 _0151_ _0154_ ui_in.2 sky130_fd_sc_hd__o21a_1
X532 _0137_ _0152_ _0153_ _0154_ sky130_fd_sc_hd__nand3_1
X533 _0153_ data_multiplex.room_temp.0 _0144_ _0148_ data_multiplex.serial_decode.data_validate.preamble.24 data_multiplex.room_temp.8 _0133_ sky130_fd_sc_hd__a222oi_1
X534 _0152_ data_multiplex.serial_decode.constant.24 _0145_ _0146_ data_multiplex.serial_decode.data_validate.preamble.16 data_multiplex.serial_decode.data_validate.preamble.8 _0138_ sky130_fd_sc_hd__a222oi_1
X535 _0149_ _0150_ _0151_ sky130_fd_sc_hd__nand2_1
X536 _0150_ data_multiplex.serial_decode.constant.0 _0141_ _0143_ data_multiplex.serial_decode.constant.16 sky130_fd_sc_hd__a22oi_1
X537 _0149_ data_multiplex.serial_decode.data_validate.type_2.0 _0140_ _0147_ data_multiplex.serial_decode.data_validate.preamble.0 data_multiplex.serial_decode.data_validate.type_2.8 _0131_ sky130_fd_sc_hd__a222oi_1
X538 _0139_ _0142_ _0148_ sky130_fd_sc_hd__nor2_1
X539 _0132_ _0139_ _0147_ sky130_fd_sc_hd__nor2_1
X540 ui_in.6 ui_in.7 _0142_ _0146_ sky130_fd_sc_hd__nor3_1
X541 ui_in.4 ui_in.5 _0135_ _0145_ sky130_fd_sc_hd__nor3_1
X542 ui_in.4 ui_in.5 _0139_ _0144_ sky130_fd_sc_hd__nor3_1
X543 _0135_ _0142_ _0143_ sky130_fd_sc_hd__nor2_1
X544 ui_in.4 _0142_ ui_in.5 sky130_fd_sc_hd__nand2b_1
X545 _0132_ _0135_ _0141_ sky130_fd_sc_hd__nor2_1
X546 _0134_ _0139_ _0140_ sky130_fd_sc_hd__nor2_1
X547 ui_in.6 _0139_ ui_in.7 sky130_fd_sc_hd__nand2b_1
X548 ui_in.6 ui_in.7 _0134_ _0138_ sky130_fd_sc_hd__nor3_1
X549 data_multiplex.serial_decode.constant.8 _0136_ _0137_ sky130_fd_sc_hd__nand2_1
X550 _0134_ _0135_ _0136_ sky130_fd_sc_hd__nor2_1
X551 ui_in.7 _0135_ ui_in.6 sky130_fd_sc_hd__nand2b_1
X552 ui_in.5 _0134_ ui_in.4 sky130_fd_sc_hd__nand2b_1
X553 ui_in.6 ui_in.7 _0132_ _0133_ sky130_fd_sc_hd__nor3_1
X554 ui_in.4 ui_in.5 _0132_ sky130_fd_sc_hd__nand2_1
X555 ui_in.4 ui_in.5 ui_in.6 ui_in.7 _0131_ sky130_fd_sc_hd__nor4_1
X556 rst_n data_multiplex.reset_n uio_out.3 sky130_fd_sc_hd__lpflow_isobufsrc_1
X557 _0000_ _0118_ _0122_ _0130_ _0119_ _0124_ sky130_fd_sc_hd__o32ai_1
X558 rst_n _0130_ state_machine.state.0 sky130_fd_sc_hd__lpflow_isobufsrc_1
X559 _0003_ _0113_ _0117_ _0129_ sky130_fd_sc_hd__o21ai_0
X560 state_machine.state.1 _0128_ _0129_ sky130_fd_sc_hd__nand2_1
X561 _0118_ _0123_ _0128_ sky130_fd_sc_hd__nor2_1
X562 _0001_ _0118_ _0125_ _0127_ sky130_fd_sc_hd__o21ai_0
X563 _0127_ rst_n state_machine.state.2 _0126_ state_machine.state.1 _0116_ sky130_fd_sc_hd__a32oi_1
X564 ui_in.2 rst_n _0126_ sky130_fd_sc_hd__and2_0
X565 state_machine.state.1 _0122_ _0123_ _0125_ sky130_fd_sc_hd__nand3_1
X566 state_machine.state.1 _0123_ _0124_ sky130_fd_sc_hd__nand2_1
X567 ui_in.0 input_edge_detect.previous_in _0123_ sky130_fd_sc_hd__xnor2_1
X568 _0122_ state_machine.timer.2 state_machine.timer.1 state_machine.timer.3 state_machine.timer.0 sky130_fd_sc_hd__o31ai_1
X569 state_machine.timer.2 state_machine.timer.1 state_machine.timer.0 _0121_ sky130_fd_sc_hd__nor3_1
X570 _0002_ _0111_ _0116_ _0120_ sky130_fd_sc_hd__o21ai_0
X571 _0120_ rst_n state_machine.state.3 _0119_ state_machine.state.0 _0113_ sky130_fd_sc_hd__a32oi_1
X572 uio_out.5 _0119_ _0118_ sky130_fd_sc_hd__lpflow_isobufsrc_1
X573 rst_n _0118_ ui_in.2 sky130_fd_sc_hd__nand2b_1
X574 rst_n state_machine.state.3 _0117_ sky130_fd_sc_hd__nand2_1
X575 ui_in.2 _0112_ _0115_ _0116_ sky130_fd_sc_hd__nor3_1
X576 state_machine.timer.3 state_machine.timer.1 state_machine.timer.0 _0115_ sky130_fd_sc_hd__nor3_1
X577 state_machine.timer.1 state_machine.timer.0 _0114_ sky130_fd_sc_hd__nor2_1
X578 ui_in.2 _0112_ _0113_ sky130_fd_sc_hd__nor2_1
X579 state_machine.timer.3 state_machine.timer.2 _0112_ sky130_fd_sc_hd__nor2_1
X580 rst_n state_machine.state.2 _0111_ sky130_fd_sc_hd__nand2_1
X581 _0110_ uio_out.0 sky130_fd_sc_hd__clkinv_1
X582 data_multiplex.serial_decode.shift_register.96 data_multiplex.serial_decode.preamble_or_data _0110_ sky130_fd_sc_hd__nand2_1
X583 input_edge_detect.previous_in uio_out.4 ui_in.0 sky130_fd_sc_hd__lpflow_isobufsrc_1
X584 ui_in.0 uio_out.5 input_edge_detect.previous_in sky130_fd_sc_hd__lpflow_isobufsrc_1
V0 data_multiplex.serial_decode.constant.0 data_multiplex.serial_decode.shift_register.0 DC 0
V1 data_multiplex.serial_decode.constant.1 data_multiplex.serial_decode.shift_register.1 DC 0
V2 data_multiplex.serial_decode.constant.2 data_multiplex.serial_decode.shift_register.2 DC 0
V3 data_multiplex.serial_decode.constant.3 data_multiplex.serial_decode.shift_register.3 DC 0
V4 data_multiplex.serial_decode.constant.4 data_multiplex.serial_decode.shift_register.4 DC 0
V5 data_multiplex.serial_decode.constant.5 data_multiplex.serial_decode.shift_register.5 DC 0
V6 data_multiplex.serial_decode.constant.6 data_multiplex.serial_decode.shift_register.6 DC 0
V7 data_multiplex.serial_decode.constant.7 data_multiplex.serial_decode.shift_register.7 DC 0
V8 data_multiplex.serial_decode.constant.8 data_multiplex.serial_decode.shift_register.8 DC 0
V9 data_multiplex.serial_decode.constant.9 data_multiplex.serial_decode.shift_register.9 DC 0
V10 data_multiplex.serial_decode.constant.10 data_multiplex.serial_decode.shift_register.10 DC 0
V11 data_multiplex.serial_decode.constant.11 data_multiplex.serial_decode.shift_register.11 DC 0
V12 data_multiplex.serial_decode.constant.12 data_multiplex.serial_decode.shift_register.12 DC 0
V13 data_multiplex.serial_decode.constant.13 data_multiplex.serial_decode.shift_register.13 DC 0
V14 data_multiplex.serial_decode.constant.14 data_multiplex.serial_decode.shift_register.14 DC 0
V15 data_multiplex.serial_decode.constant.15 data_multiplex.serial_decode.shift_register.15 DC 0
V16 data_multiplex.serial_decode.constant.16 data_multiplex.serial_decode.shift_register.16 DC 0
V17 data_multiplex.serial_decode.constant.17 data_multiplex.serial_decode.shift_register.17 DC 0
V18 data_multiplex.serial_decode.constant.18 data_multiplex.serial_decode.shift_register.18 DC 0
V19 data_multiplex.serial_decode.constant.19 data_multiplex.serial_decode.shift_register.19 DC 0
V20 data_multiplex.serial_decode.constant.20 data_multiplex.serial_decode.shift_register.20 DC 0
V21 data_multiplex.serial_decode.constant.21 data_multiplex.serial_decode.shift_register.21 DC 0
V22 data_multiplex.serial_decode.constant.22 data_multiplex.serial_decode.shift_register.22 DC 0
V23 data_multiplex.serial_decode.constant.23 data_multiplex.serial_decode.shift_register.23 DC 0
V24 data_multiplex.serial_decode.constant.24 data_multiplex.serial_decode.shift_register.24 DC 0
V25 data_multiplex.serial_decode.constant.25 data_multiplex.serial_decode.shift_register.25 DC 0
V26 data_multiplex.serial_decode.constant.26 data_multiplex.serial_decode.shift_register.26 DC 0
V27 data_multiplex.serial_decode.constant.27 data_multiplex.serial_decode.shift_register.27 DC 0
V28 data_multiplex.serial_decode.constant.28 data_multiplex.serial_decode.shift_register.28 DC 0
V29 data_multiplex.serial_decode.constant.29 data_multiplex.serial_decode.shift_register.29 DC 0
V30 data_multiplex.serial_decode.constant.30 data_multiplex.serial_decode.shift_register.30 DC 0
V31 data_multiplex.serial_decode.constant.31 data_multiplex.serial_decode.shift_register.31 DC 0
V32 data_multiplex.serial_decode.data_validate.type_2.0 data_multiplex.serial_decode.shift_register.32 DC 0
V33 data_multiplex.serial_decode.data_validate.type_2.1 data_multiplex.serial_decode.shift_register.33 DC 0
V34 data_multiplex.serial_decode.data_validate.type_2.2 data_multiplex.serial_decode.shift_register.34 DC 0
V35 data_multiplex.serial_decode.data_validate.type_2.3 data_multiplex.serial_decode.shift_register.35 DC 0
V36 data_multiplex.serial_decode.data_validate.type_2.4 data_multiplex.serial_decode.shift_register.36 DC 0
V37 data_multiplex.serial_decode.data_validate.type_2.5 data_multiplex.serial_decode.shift_register.37 DC 0
V38 data_multiplex.serial_decode.data_validate.type_2.6 data_multiplex.serial_decode.shift_register.38 DC 0
V39 data_multiplex.serial_decode.data_validate.type_2.7 data_multiplex.serial_decode.shift_register.39 DC 0
V40 data_multiplex.serial_decode.data_validate.type_2.8 data_multiplex.serial_decode.shift_register.40 DC 0
V41 data_multiplex.serial_decode.data_validate.type_2.9 data_multiplex.serial_decode.shift_register.41 DC 0
V42 data_multiplex.serial_decode.data_validate.type_2.10 data_multiplex.serial_decode.shift_register.42 DC 0
V43 data_multiplex.serial_decode.data_validate.type_2.11 data_multiplex.serial_decode.shift_register.43 DC 0
V44 data_multiplex.serial_decode.data_validate.type_2.12 data_multiplex.serial_decode.shift_register.44 DC 0
V45 data_multiplex.serial_decode.data_validate.type_2.13 data_multiplex.serial_decode.shift_register.45 DC 0
V46 data_multiplex.serial_decode.data_validate.type_2.14 data_multiplex.serial_decode.shift_register.46 DC 0
V47 data_multiplex.serial_decode.data_validate.type_2.15 data_multiplex.serial_decode.shift_register.47 DC 0
V48 data_multiplex.room_temp.0 data_multiplex.serial_decode.shift_register.48 DC 0
V49 data_multiplex.room_temp.1 data_multiplex.serial_decode.shift_register.49 DC 0
V50 data_multiplex.room_temp.2 data_multiplex.serial_decode.shift_register.50 DC 0
V51 data_multiplex.room_temp.3 data_multiplex.serial_decode.shift_register.51 DC 0
V52 data_multiplex.room_temp.4 data_multiplex.serial_decode.shift_register.52 DC 0
V53 data_multiplex.room_temp.5 data_multiplex.serial_decode.shift_register.53 DC 0
V54 data_multiplex.room_temp.6 data_multiplex.serial_decode.shift_register.54 DC 0
V55 data_multiplex.room_temp.7 data_multiplex.serial_decode.shift_register.55 DC 0
V56 data_multiplex.room_temp.8 data_multiplex.serial_decode.shift_register.56 DC 0
V57 data_multiplex.room_temp.9 data_multiplex.serial_decode.shift_register.57 DC 0
V58 data_multiplex.room_temp.10 data_multiplex.serial_decode.shift_register.58 DC 0
V59 data_multiplex.room_temp.11 data_multiplex.serial_decode.shift_register.59 DC 0
V60 data_multiplex.room_temp.12 data_multiplex.serial_decode.shift_register.60 DC 0
V61 data_multiplex.room_temp.13 data_multiplex.serial_decode.shift_register.61 DC 0
V62 data_multiplex.room_temp.14 data_multiplex.serial_decode.shift_register.62 DC 0
V63 data_multiplex.room_temp.15 data_multiplex.serial_decode.shift_register.63 DC 0
V64 data_multiplex.serial_decode.data_validate.preamble.0 data_multiplex.serial_decode.shift_register.64 DC 0
V65 data_multiplex.serial_decode.data_validate.preamble.1 data_multiplex.serial_decode.shift_register.65 DC 0
V66 data_multiplex.serial_decode.data_validate.preamble.2 data_multiplex.serial_decode.shift_register.66 DC 0
V67 data_multiplex.serial_decode.data_validate.preamble.3 data_multiplex.serial_decode.shift_register.67 DC 0
V68 data_multiplex.serial_decode.data_validate.preamble.4 data_multiplex.serial_decode.shift_register.68 DC 0
V69 data_multiplex.serial_decode.data_validate.preamble.5 data_multiplex.serial_decode.shift_register.69 DC 0
V70 data_multiplex.serial_decode.data_validate.preamble.6 data_multiplex.serial_decode.shift_register.70 DC 0
V71 data_multiplex.serial_decode.data_validate.preamble.7 data_multiplex.serial_decode.shift_register.71 DC 0
V72 data_multiplex.serial_decode.data_validate.preamble.8 data_multiplex.serial_decode.shift_register.72 DC 0
V73 data_multiplex.serial_decode.data_validate.preamble.9 data_multiplex.serial_decode.shift_register.73 DC 0
V74 data_multiplex.serial_decode.data_validate.preamble.10 data_multiplex.serial_decode.shift_register.74 DC 0
V75 data_multiplex.serial_decode.data_validate.preamble.11 data_multiplex.serial_decode.shift_register.75 DC 0
V76 data_multiplex.serial_decode.data_validate.preamble.12 data_multiplex.serial_decode.shift_register.76 DC 0
V77 data_multiplex.serial_decode.data_validate.preamble.13 data_multiplex.serial_decode.shift_register.77 DC 0
V78 data_multiplex.serial_decode.data_validate.preamble.14 data_multiplex.serial_decode.shift_register.78 DC 0
V79 data_multiplex.serial_decode.data_validate.preamble.15 data_multiplex.serial_decode.shift_register.79 DC 0
V80 data_multiplex.serial_decode.data_validate.preamble.16 data_multiplex.serial_decode.shift_register.80 DC 0
V81 data_multiplex.serial_decode.data_validate.preamble.17 data_multiplex.serial_decode.shift_register.81 DC 0
V82 data_multiplex.serial_decode.data_validate.preamble.18 data_multiplex.serial_decode.shift_register.82 DC 0
V83 data_multiplex.serial_decode.data_validate.preamble.19 data_multiplex.serial_decode.shift_register.83 DC 0
V84 data_multiplex.serial_decode.data_validate.preamble.20 data_multiplex.serial_decode.shift_register.84 DC 0
V85 data_multiplex.serial_decode.data_validate.preamble.21 data_multiplex.serial_decode.shift_register.85 DC 0
V86 data_multiplex.serial_decode.data_validate.preamble.22 data_multiplex.serial_decode.shift_register.86 DC 0
V87 data_multiplex.serial_decode.data_validate.preamble.23 data_multiplex.serial_decode.shift_register.87 DC 0
V88 data_multiplex.serial_decode.data_validate.preamble.24 data_multiplex.serial_decode.shift_register.88 DC 0
V89 data_multiplex.serial_decode.data_validate.preamble.25 data_multiplex.serial_decode.shift_register.89 DC 0
V90 data_multiplex.serial_decode.data_validate.preamble.26 data_multiplex.serial_decode.shift_register.90 DC 0
V91 data_multiplex.serial_decode.data_validate.preamble.27 data_multiplex.serial_decode.shift_register.91 DC 0
V92 data_multiplex.serial_decode.data_validate.preamble.28 data_multiplex.serial_decode.shift_register.92 DC 0
V93 data_multiplex.serial_decode.data_validate.preamble.29 data_multiplex.serial_decode.shift_register.93 DC 0
V94 data_multiplex.serial_decode.data_validate.preamble.30 data_multiplex.serial_decode.shift_register.94 DC 0
V95 data_multiplex.serial_decode.data_validate.preamble.31 data_multiplex.serial_decode.shift_register.95 DC 0
.ENDS tt_um_dusterthefirst_project

************************
* end of SPICE netlist *
************************
