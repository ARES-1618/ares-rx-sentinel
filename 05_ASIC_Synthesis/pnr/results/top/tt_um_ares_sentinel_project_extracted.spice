* NGSPICE file created from tt_um_ares_sentinel_project.ext - technology: sky130A

.subckt sky130_fd_sc_hd__dfrtp_1 VGND VPWR VPB VNB CLK D RESET_B Q
X0 a_1217_47# a_27_47# a_1108_47# VNB sky130_fd_pr__nfet_01v8 ad=0.0669 pd=0.75 as=0.0711 ps=0.755 w=0.36 l=0.15
X1 a_805_47# a_761_289# a_639_47# VNB sky130_fd_pr__nfet_01v8 ad=0.0441 pd=0.63 as=0.1401 ps=1.1 w=0.42 l=0.15
X2 a_1108_47# a_193_47# a_761_289# VNB sky130_fd_pr__nfet_01v8 ad=0.0711 pd=0.755 as=0.0999 ps=0.985 w=0.36 l=0.15
X3 a_1283_21# a_1108_47# a_1462_47# VNB sky130_fd_pr__nfet_01v8 ad=0.1092 pd=1.36 as=0.06405 ps=0.725 w=0.42 l=0.15
X4 a_651_413# a_27_47# a_543_47# VPB sky130_fd_pr__pfet_01v8_hvt ad=0.1155 pd=0.97 as=0.07245 ps=0.765 w=0.42 l=0.15
X5 VGND RESET_B a_805_47# VNB sky130_fd_pr__nfet_01v8 ad=0.1346 pd=1.15 as=0.0441 ps=0.63 w=0.42 l=0.15
X6 Q a_1283_21# VPWR VPB sky130_fd_pr__pfet_01v8_hvt ad=0.26 pd=2.52 as=0.3012 ps=2.66 w=1 l=0.15
X7 VPWR CLK a_27_47# VPB sky130_fd_pr__pfet_01v8_hvt ad=0.0864 pd=0.91 as=0.1664 ps=1.8 w=0.64 l=0.15
X8 a_448_47# D VPWR VPB sky130_fd_pr__pfet_01v8_hvt ad=0.0651 pd=0.73 as=0.1092 ps=1.36 w=0.42 l=0.15
X9 a_761_289# a_543_47# VGND VNB sky130_fd_pr__nfet_01v8 ad=0.0999 pd=0.985 as=0.1346 ps=1.15 w=0.64 l=0.15
X10 a_193_47# a_27_47# VGND VNB sky130_fd_pr__nfet_01v8 ad=0.1092 pd=1.36 as=0.0567 ps=0.69 w=0.42 l=0.15
X11 a_1108_47# a_27_47# a_761_289# VPB sky130_fd_pr__pfet_01v8_hvt ad=0.0588 pd=0.7 as=0.12915 ps=1.185 w=0.42 l=0.15
X12 a_543_47# a_27_47# a_448_47# VNB sky130_fd_pr__nfet_01v8 ad=0.0594 pd=0.69 as=0.066 ps=0.745 w=0.36 l=0.15
X13 a_1462_47# RESET_B VGND VNB sky130_fd_pr__nfet_01v8 ad=0.06405 pd=0.725 as=0.12495 ps=1.015 w=0.42 l=0.15
X14 a_543_47# a_193_47# a_448_47# VPB sky130_fd_pr__pfet_01v8_hvt ad=0.07245 pd=0.765 as=0.0651 ps=0.73 w=0.42 l=0.15
X15 a_448_47# D VGND VNB sky130_fd_pr__nfet_01v8 ad=0.066 pd=0.745 as=0.2205 ps=1.89 w=0.42 l=0.15
X16 VPWR a_1283_21# a_1270_413# VPB sky130_fd_pr__pfet_01v8_hvt ad=0.0819 pd=0.81 as=0.0567 ps=0.69 w=0.42 l=0.15
X17 VPWR a_1108_47# a_1283_21# VPB sky130_fd_pr__pfet_01v8_hvt ad=0.1134 pd=1.38 as=0.0567 ps=0.69 w=0.42 l=0.15
X18 a_1270_413# a_193_47# a_1108_47# VPB sky130_fd_pr__pfet_01v8_hvt ad=0.0567 pd=0.69 as=0.0588 ps=0.7 w=0.42 l=0.15
X19 a_193_47# a_27_47# VPWR VPB sky130_fd_pr__pfet_01v8_hvt ad=0.1664 pd=1.8 as=0.0864 ps=0.91 w=0.64 l=0.15
X20 a_1283_21# RESET_B VPWR VPB sky130_fd_pr__pfet_01v8_hvt ad=0.0567 pd=0.69 as=0.0819 ps=0.81 w=0.42 l=0.15
X21 VPWR a_761_289# a_651_413# VPB sky130_fd_pr__pfet_01v8_hvt ad=0.07035 pd=0.755 as=0.1155 ps=0.97 w=0.42 l=0.15
X22 Q a_1283_21# VGND VNB sky130_fd_pr__nfet_01v8 ad=0.169 pd=1.82 as=0.2087 ps=2.02 w=0.65 l=0.15
X23 a_639_47# a_193_47# a_543_47# VNB sky130_fd_pr__nfet_01v8 ad=0.1401 pd=1.1 as=0.0594 ps=0.69 w=0.36 l=0.15
X24 VGND a_1283_21# a_1217_47# VNB sky130_fd_pr__nfet_01v8 ad=0.12495 pd=1.015 as=0.0669 ps=0.75 w=0.42 l=0.15
X25 a_651_413# RESET_B VPWR VPB sky130_fd_pr__pfet_01v8_hvt ad=0.1092 pd=1.36 as=0.07035 ps=0.755 w=0.42 l=0.15
X26 VGND CLK a_27_47# VNB sky130_fd_pr__nfet_01v8 ad=0.0567 pd=0.69 as=0.1092 ps=1.36 w=0.42 l=0.15
X27 a_761_289# a_543_47# VPWR VPB sky130_fd_pr__pfet_01v8_hvt ad=0.12915 pd=1.185 as=0.2184 ps=2.2 w=0.84 l=0.15
.ends

.subckt sky130_fd_sc_hd__nand2_1 VPB VNB VGND VPWR A Y B
X0 VPWR A Y VPB sky130_fd_pr__pfet_01v8_hvt ad=0.26 pd=2.52 as=0.135 ps=1.27 w=1 l=0.15
X1 Y A a_113_47# VNB sky130_fd_pr__nfet_01v8 ad=0.169 pd=1.82 as=0.08775 ps=0.92 w=0.65 l=0.15
X2 a_113_47# B VGND VNB sky130_fd_pr__nfet_01v8 ad=0.08775 pd=0.92 as=0.169 ps=1.82 w=0.65 l=0.15
X3 Y B VPWR VPB sky130_fd_pr__pfet_01v8_hvt ad=0.135 pd=1.27 as=0.26 ps=2.52 w=1 l=0.15
.ends

.subckt sky130_fd_sc_hd__a31oi_1 VGND VPWR VPB VNB A3 A2 A1 Y B1
X0 Y A1 a_181_47# VNB sky130_fd_pr__nfet_01v8 ad=0.10563 pd=0.975 as=0.11863 ps=1.015 w=0.65 l=0.15
X1 a_181_47# A2 a_109_47# VNB sky130_fd_pr__nfet_01v8 ad=0.11863 pd=1.015 as=0.06825 ps=0.86 w=0.65 l=0.15
X2 VGND B1 Y VNB sky130_fd_pr__nfet_01v8 ad=0.1755 pd=1.84 as=0.10563 ps=0.975 w=0.65 l=0.15
X3 VPWR A2 a_109_297# VPB sky130_fd_pr__pfet_01v8_hvt ad=0.1525 pd=1.305 as=0.135 ps=1.27 w=1 l=0.15
X4 Y B1 a_109_297# VPB sky130_fd_pr__pfet_01v8_hvt ad=0.27 pd=2.54 as=0.1625 ps=1.325 w=1 l=0.15
X5 a_109_297# A1 VPWR VPB sky130_fd_pr__pfet_01v8_hvt ad=0.1625 pd=1.325 as=0.1525 ps=1.305 w=1 l=0.15
X6 a_109_297# A3 VPWR VPB sky130_fd_pr__pfet_01v8_hvt ad=0.135 pd=1.27 as=0.26 ps=2.52 w=1 l=0.15
X7 a_109_47# A3 VGND VNB sky130_fd_pr__nfet_01v8 ad=0.06825 pd=0.86 as=0.169 ps=1.82 w=0.65 l=0.15
.ends

.subckt sky130_fd_sc_hd__dfxtp_1 Q CLK D VPB VNB VPWR VGND
X0 Q a_1059_315# VGND VNB sky130_fd_pr__nfet_01v8 ad=0.169 pd=1.82 as=0.08775 ps=0.92 w=0.65 l=0.15
X1 a_891_413# a_193_47# a_634_159# VNB sky130_fd_pr__nfet_01v8 ad=0.0684 pd=0.74 as=0.0989 ps=0.995 w=0.36 l=0.15
X2 a_561_413# a_27_47# a_466_413# VPB sky130_fd_pr__pfet_01v8_hvt ad=0.07665 pd=0.785 as=0.06825 ps=0.745 w=0.42 l=0.15
X3 VPWR CLK a_27_47# VPB sky130_fd_pr__pfet_01v8_hvt ad=0.0864 pd=0.91 as=0.1664 ps=1.8 w=0.64 l=0.15
X4 Q a_1059_315# VPWR VPB sky130_fd_pr__pfet_01v8_hvt ad=0.26 pd=2.52 as=0.135 ps=1.27 w=1 l=0.15
X5 a_381_47# D VPWR VPB sky130_fd_pr__pfet_01v8_hvt ad=0.05775 pd=0.695 as=0.1092 ps=1.36 w=0.42 l=0.15
X6 VGND a_634_159# a_592_47# VNB sky130_fd_pr__nfet_01v8 ad=0.12095 pd=1.085 as=0.0696 ps=0.765 w=0.42 l=0.15
X7 VPWR a_891_413# a_1059_315# VPB sky130_fd_pr__pfet_01v8_hvt ad=0.135 pd=1.27 as=0.27 ps=2.54 w=1 l=0.15
X8 a_466_413# a_193_47# a_381_47# VPB sky130_fd_pr__pfet_01v8_hvt ad=0.06825 pd=0.745 as=0.05775 ps=0.695 w=0.42 l=0.15
X9 VPWR a_634_159# a_561_413# VPB sky130_fd_pr__pfet_01v8_hvt ad=0.17887 pd=1.26 as=0.07665 ps=0.785 w=0.42 l=0.15
X10 a_634_159# a_466_413# VGND VNB sky130_fd_pr__nfet_01v8 ad=0.0989 pd=0.995 as=0.12095 ps=1.085 w=0.64 l=0.15
X11 a_634_159# a_466_413# VPWR VPB sky130_fd_pr__pfet_01v8_hvt ad=0.1095 pd=1.075 as=0.17887 ps=1.26 w=0.75 l=0.15
X12 a_975_413# a_193_47# a_891_413# VPB sky130_fd_pr__pfet_01v8_hvt ad=0.0882 pd=0.84 as=0.0567 ps=0.69 w=0.42 l=0.15
X13 VGND a_1059_315# a_1017_47# VNB sky130_fd_pr__nfet_01v8 ad=0.1092 pd=1.36 as=0.066 ps=0.745 w=0.42 l=0.15
X14 a_193_47# a_27_47# VGND VNB sky130_fd_pr__nfet_01v8 ad=0.1092 pd=1.36 as=0.0567 ps=0.69 w=0.42 l=0.15
X15 a_891_413# a_27_47# a_634_159# VPB sky130_fd_pr__pfet_01v8_hvt ad=0.0567 pd=0.69 as=0.1095 ps=1.075 w=0.42 l=0.15
X16 a_592_47# a_193_47# a_466_413# VNB sky130_fd_pr__nfet_01v8 ad=0.0696 pd=0.765 as=0.0621 ps=0.705 w=0.36 l=0.15
X17 a_1017_47# a_27_47# a_891_413# VNB sky130_fd_pr__nfet_01v8 ad=0.066 pd=0.745 as=0.0684 ps=0.74 w=0.36 l=0.15
X18 VPWR a_1059_315# a_975_413# VPB sky130_fd_pr__pfet_01v8_hvt ad=0.1113 pd=1.37 as=0.0882 ps=0.84 w=0.42 l=0.15
X19 a_466_413# a_27_47# a_381_47# VNB sky130_fd_pr__nfet_01v8 ad=0.0621 pd=0.705 as=0.0813 ps=0.83 w=0.36 l=0.15
X20 a_193_47# a_27_47# VPWR VPB sky130_fd_pr__pfet_01v8_hvt ad=0.1664 pd=1.8 as=0.0864 ps=0.91 w=0.64 l=0.15
X21 VGND a_891_413# a_1059_315# VNB sky130_fd_pr__nfet_01v8 ad=0.08775 pd=0.92 as=0.169 ps=1.82 w=0.65 l=0.15
X22 a_381_47# D VGND VNB sky130_fd_pr__nfet_01v8 ad=0.0813 pd=0.83 as=0.1092 ps=1.36 w=0.42 l=0.15
X23 VGND CLK a_27_47# VNB sky130_fd_pr__nfet_01v8 ad=0.0567 pd=0.69 as=0.1092 ps=1.36 w=0.42 l=0.15
.ends

.subckt sky130_fd_sc_hd__clkbuf_2 VGND VPWR A X VPB VNB
X0 VPWR A a_27_47# VPB sky130_fd_pr__pfet_01v8_hvt ad=0.1625 pd=1.325 as=0.265 ps=2.53 w=1 l=0.15
X1 VPWR a_27_47# X VPB sky130_fd_pr__pfet_01v8_hvt ad=0.26 pd=2.52 as=0.135 ps=1.27 w=1 l=0.15
X2 VGND A a_27_47# VNB sky130_fd_pr__nfet_01v8 ad=0.06825 pd=0.745 as=0.1113 ps=1.37 w=0.42 l=0.15
X3 X a_27_47# VPWR VPB sky130_fd_pr__pfet_01v8_hvt ad=0.135 pd=1.27 as=0.1625 ps=1.325 w=1 l=0.15
X4 X a_27_47# VGND VNB sky130_fd_pr__nfet_01v8 ad=0.0567 pd=0.69 as=0.06825 ps=0.745 w=0.42 l=0.15
X5 VGND a_27_47# X VNB sky130_fd_pr__nfet_01v8 ad=0.1092 pd=1.36 as=0.0567 ps=0.69 w=0.42 l=0.15
.ends

.subckt sky130_fd_sc_hd__nand4_1 VPB VNB VPWR VGND A C D Y B
X0 Y B VPWR VPB sky130_fd_pr__pfet_01v8_hvt ad=0.165 pd=1.33 as=0.135 ps=1.27 w=1 l=0.15
X1 VPWR A Y VPB sky130_fd_pr__pfet_01v8_hvt ad=0.3 pd=2.6 as=0.165 ps=1.33 w=1 l=0.15
X2 VPWR C Y VPB sky130_fd_pr__pfet_01v8_hvt ad=0.135 pd=1.27 as=0.135 ps=1.27 w=1 l=0.15
X3 a_193_47# C a_109_47# VNB sky130_fd_pr__nfet_01v8 ad=0.08775 pd=0.92 as=0.08775 ps=0.92 w=0.65 l=0.15
X4 Y A a_277_47# VNB sky130_fd_pr__nfet_01v8 ad=0.195 pd=1.9 as=0.10725 ps=0.98 w=0.65 l=0.15
X5 a_277_47# B a_193_47# VNB sky130_fd_pr__nfet_01v8 ad=0.10725 pd=0.98 as=0.08775 ps=0.92 w=0.65 l=0.15
X6 Y D VPWR VPB sky130_fd_pr__pfet_01v8_hvt ad=0.135 pd=1.27 as=0.26 ps=2.52 w=1 l=0.15
X7 a_109_47# D VGND VNB sky130_fd_pr__nfet_01v8 ad=0.08775 pd=0.92 as=0.169 ps=1.82 w=0.65 l=0.15
.ends

.subckt sky130_fd_sc_hd__nor2_1 VPB VNB VGND VPWR A B Y
X0 VPWR A a_109_297# VPB sky130_fd_pr__pfet_01v8_hvt ad=0.26 pd=2.52 as=0.105 ps=1.21 w=1 l=0.15
X1 VGND A Y VNB sky130_fd_pr__nfet_01v8 ad=0.169 pd=1.82 as=0.08775 ps=0.92 w=0.65 l=0.15
X2 a_109_297# B Y VPB sky130_fd_pr__pfet_01v8_hvt ad=0.105 pd=1.21 as=0.26 ps=2.52 w=1 l=0.15
X3 Y B VGND VNB sky130_fd_pr__nfet_01v8 ad=0.08775 pd=0.92 as=0.169 ps=1.82 w=0.65 l=0.15
.ends

.subckt sky130_fd_sc_hd__and3_1 VGND VPWR X B A C VPB VNB
X0 VPWR A a_27_47# VPB sky130_fd_pr__pfet_01v8_hvt ad=0.0567 pd=0.69 as=0.1092 ps=1.36 w=0.42 l=0.15
X1 VPWR C a_27_47# VPB sky130_fd_pr__pfet_01v8_hvt ad=0.14222 pd=1.335 as=0.06615 ps=0.735 w=0.42 l=0.15
X2 a_181_47# B a_109_47# VNB sky130_fd_pr__nfet_01v8 ad=0.0441 pd=0.63 as=0.0441 ps=0.63 w=0.42 l=0.15
X3 VGND C a_181_47# VNB sky130_fd_pr__nfet_01v8 ad=0.13165 pd=1.14 as=0.0441 ps=0.63 w=0.42 l=0.15
X4 a_27_47# B VPWR VPB sky130_fd_pr__pfet_01v8_hvt ad=0.06615 pd=0.735 as=0.0567 ps=0.69 w=0.42 l=0.15
X5 X a_27_47# VPWR VPB sky130_fd_pr__pfet_01v8_hvt ad=0.26 pd=2.52 as=0.14222 ps=1.335 w=1 l=0.15
X6 X a_27_47# VGND VNB sky130_fd_pr__nfet_01v8 ad=0.169 pd=1.82 as=0.13165 ps=1.14 w=0.65 l=0.15
X7 a_109_47# A a_27_47# VNB sky130_fd_pr__nfet_01v8 ad=0.0441 pd=0.63 as=0.1092 ps=1.36 w=0.42 l=0.15
.ends

.subckt sky130_fd_sc_hd__a22o_1 VPWR VGND VPB VNB B1 A1 A2 X B2
X0 VPWR A2 a_109_297# VPB sky130_fd_pr__pfet_01v8_hvt ad=0.155 pd=1.31 as=0.16 ps=1.32 w=1 l=0.15
X1 a_27_297# B1 a_109_47# VNB sky130_fd_pr__nfet_01v8 ad=0.169 pd=1.82 as=0.07475 ps=0.88 w=0.65 l=0.15
X2 VGND A2 a_373_47# VNB sky130_fd_pr__nfet_01v8 ad=0.10075 pd=0.96 as=0.11375 ps=1 w=0.65 l=0.15
X3 X a_27_297# VPWR VPB sky130_fd_pr__pfet_01v8_hvt ad=0.26 pd=2.52 as=0.155 ps=1.31 w=1 l=0.15
X4 a_27_297# B1 a_109_297# VPB sky130_fd_pr__pfet_01v8_hvt ad=0.25285 pd=2.52 as=0.135 ps=1.27 w=1 l=0.15
X5 a_109_297# A1 VPWR VPB sky130_fd_pr__pfet_01v8_hvt ad=0.16 pd=1.32 as=0.2529 ps=2.52 w=1 l=0.15
X6 a_373_47# A1 a_27_297# VNB sky130_fd_pr__nfet_01v8 ad=0.11375 pd=1 as=0.169 ps=1.82 w=0.65 l=0.15
X7 X a_27_297# VGND VNB sky130_fd_pr__nfet_01v8 ad=0.169 pd=1.82 as=0.10075 ps=0.96 w=0.65 l=0.15
X8 a_109_297# B2 a_27_297# VPB sky130_fd_pr__pfet_01v8_hvt ad=0.135 pd=1.27 as=0.26 ps=2.52 w=1 l=0.15
X9 a_109_47# B2 VGND VNB sky130_fd_pr__nfet_01v8 ad=0.07475 pd=0.88 as=0.169 ps=1.82 w=0.65 l=0.15
.ends

.subckt sky130_fd_sc_hd__a32oi_1 VGND VPWR VPB VNB B2 Y B1 A1 A2 A3
X0 VPWR A3 a_27_297# VPB sky130_fd_pr__pfet_01v8_hvt ad=0.26 pd=2.52 as=0.14 ps=1.28 w=1 l=0.15
X1 VGND A3 a_383_47# VNB sky130_fd_pr__nfet_01v8 ad=0.169 pd=1.82 as=0.10725 ps=0.98 w=0.65 l=0.15
X2 a_309_47# A1 Y VNB sky130_fd_pr__nfet_01v8 ad=0.0715 pd=0.87 as=0.15275 ps=1.12 w=0.65 l=0.15
X3 Y B1 a_109_47# VNB sky130_fd_pr__nfet_01v8 ad=0.15275 pd=1.12 as=0.07475 ps=0.88 w=0.65 l=0.15
X4 a_27_297# B1 Y VPB sky130_fd_pr__pfet_01v8_hvt ad=0.215 pd=1.43 as=0.135 ps=1.27 w=1 l=0.15
X5 a_383_47# A2 a_309_47# VNB sky130_fd_pr__nfet_01v8 ad=0.10725 pd=0.98 as=0.0715 ps=0.87 w=0.65 l=0.15
X6 a_27_297# A2 VPWR VPB sky130_fd_pr__pfet_01v8_hvt ad=0.14 pd=1.28 as=0.135 ps=1.27 w=1 l=0.15
X7 Y B2 a_27_297# VPB sky130_fd_pr__pfet_01v8_hvt ad=0.135 pd=1.27 as=0.26 ps=2.52 w=1 l=0.15
X8 VPWR A1 a_27_297# VPB sky130_fd_pr__pfet_01v8_hvt ad=0.135 pd=1.27 as=0.215 ps=1.43 w=1 l=0.15
X9 a_109_47# B2 VGND VNB sky130_fd_pr__nfet_01v8 ad=0.07475 pd=0.88 as=0.169 ps=1.82 w=0.65 l=0.15
.ends

.subckt sky130_fd_sc_hd__a222oi_1 VNB VPB VPWR VGND C2 C1 B1 A2 A1 Y B2
X0 Y B1 a_393_47# VNB sky130_fd_pr__nfet_01v8 ad=0.1056 pd=0.97 as=0.0672 ps=0.85 w=0.64 l=0.15
X1 VGND A2 a_561_47# VNB sky130_fd_pr__nfet_01v8 ad=0.1664 pd=1.8 as=0.1056 ps=0.97 w=0.64 l=0.15
X2 VGND C2 a_109_47# VNB sky130_fd_pr__nfet_01v8 ad=0.2912 pd=1.55 as=0.0672 ps=0.85 w=0.64 l=0.15
X3 Y C2 a_109_297# VPB sky130_fd_pr__pfet_01v8_hvt ad=0.26 pd=2.52 as=0.135 ps=1.27 w=1 l=0.15
X4 VPWR A1 a_311_297# VPB sky130_fd_pr__pfet_01v8_hvt ad=0.165 pd=1.33 as=0.135 ps=1.27 w=1 l=0.15
X5 a_311_297# A2 VPWR VPB sky130_fd_pr__pfet_01v8_hvt ad=0.26 pd=2.52 as=0.165 ps=1.33 w=1 l=0.15
X6 a_311_297# B1 a_109_297# VPB sky130_fd_pr__pfet_01v8_hvt ad=0.135 pd=1.27 as=0.135 ps=1.27 w=1 l=0.15
X7 a_109_297# B2 a_311_297# VPB sky130_fd_pr__pfet_01v8_hvt ad=0.135 pd=1.27 as=0.26 ps=2.52 w=1 l=0.15
X8 a_109_297# C1 Y VPB sky130_fd_pr__pfet_01v8_hvt ad=0.135 pd=1.27 as=0.26 ps=2.52 w=1 l=0.15
X9 a_393_47# B2 VGND VNB sky130_fd_pr__nfet_01v8 ad=0.0672 pd=0.85 as=0.2912 ps=1.55 w=0.64 l=0.15
X10 a_109_47# C1 Y VNB sky130_fd_pr__nfet_01v8 ad=0.0672 pd=0.85 as=0.1664 ps=1.8 w=0.64 l=0.15
X11 a_561_47# A1 Y VNB sky130_fd_pr__nfet_01v8 ad=0.1056 pd=0.97 as=0.1056 ps=0.97 w=0.64 l=0.15
.ends

.subckt sky130_fd_sc_hd__o21ai_0 VNB VPB VGND VPWR B1 A1 Y A2
X0 a_120_369# A1 VPWR VPB sky130_fd_pr__pfet_01v8_hvt ad=0.0768 pd=0.88 as=0.1696 ps=1.81 w=0.64 l=0.15
X1 VGND A1 a_32_47# VNB sky130_fd_pr__nfet_01v8 ad=0.0588 pd=0.7 as=0.1113 ps=1.37 w=0.42 l=0.15
X2 Y A2 a_120_369# VPB sky130_fd_pr__pfet_01v8_hvt ad=0.0896 pd=0.92 as=0.0768 ps=0.88 w=0.64 l=0.15
X3 a_32_47# A2 VGND VNB sky130_fd_pr__nfet_01v8 ad=0.0588 pd=0.7 as=0.0588 ps=0.7 w=0.42 l=0.15
X4 VPWR B1 Y VPB sky130_fd_pr__pfet_01v8_hvt ad=0.1824 pd=1.85 as=0.0896 ps=0.92 w=0.64 l=0.15
X5 Y B1 a_32_47# VNB sky130_fd_pr__nfet_01v8 ad=0.1113 pd=1.37 as=0.0588 ps=0.7 w=0.42 l=0.15
.ends

.subckt sky130_fd_sc_hd__nor4b_1 VPB VNB VGND VPWR D_N C Y B A
X0 Y a_91_199# VGND VNB sky130_fd_pr__nfet_01v8 ad=0.08775 pd=0.92 as=0.182 ps=1.86 w=0.65 l=0.15
X1 Y B VGND VNB sky130_fd_pr__nfet_01v8 ad=0.08775 pd=0.92 as=0.10725 ps=0.98 w=0.65 l=0.15
X2 VGND C Y VNB sky130_fd_pr__nfet_01v8 ad=0.10725 pd=0.98 as=0.08775 ps=0.92 w=0.65 l=0.15
X3 a_91_199# D_N VGND VNB sky130_fd_pr__nfet_01v8 ad=0.1092 pd=1.36 as=0.10025 ps=0.985 w=0.42 l=0.15
X4 VGND A Y VNB sky130_fd_pr__nfet_01v8 ad=0.10025 pd=0.985 as=0.08775 ps=0.92 w=0.65 l=0.15
X5 VPWR A a_341_297# VPB sky130_fd_pr__pfet_01v8_hvt ad=0.14575 pd=1.335 as=0.135 ps=1.27 w=1 l=0.15
X6 a_245_297# C a_161_297# VPB sky130_fd_pr__pfet_01v8_hvt ad=0.165 pd=1.33 as=0.135 ps=1.27 w=1 l=0.15
X7 a_341_297# B a_245_297# VPB sky130_fd_pr__pfet_01v8_hvt ad=0.135 pd=1.27 as=0.165 ps=1.33 w=1 l=0.15
X8 a_91_199# D_N VPWR VPB sky130_fd_pr__pfet_01v8_hvt ad=0.1092 pd=1.36 as=0.14575 ps=1.335 w=0.42 l=0.15
X9 a_161_297# a_91_199# Y VPB sky130_fd_pr__pfet_01v8_hvt ad=0.135 pd=1.27 as=0.52 ps=3.04 w=1 l=0.15
.ends

.subckt sky130_fd_sc_hd__nor3b_1 VPB VNB VGND VPWR C_N B Y A
X0 VGND a_91_199# Y VNB sky130_fd_pr__nfet_01v8 ad=0.08775 pd=0.92 as=0.221 ps=1.98 w=0.65 l=0.15
X1 Y B VGND VNB sky130_fd_pr__nfet_01v8 ad=0.08775 pd=0.92 as=0.08775 ps=0.92 w=0.65 l=0.15
X2 VPWR A a_245_297# VPB sky130_fd_pr__pfet_01v8_hvt ad=0.14575 pd=1.335 as=0.135 ps=1.27 w=1 l=0.15
X3 a_91_199# C_N VGND VNB sky130_fd_pr__nfet_01v8 ad=0.1092 pd=1.36 as=0.10025 ps=0.985 w=0.42 l=0.15
X4 VGND A Y VNB sky130_fd_pr__nfet_01v8 ad=0.10025 pd=0.985 as=0.08775 ps=0.92 w=0.65 l=0.15
X5 a_245_297# B a_161_297# VPB sky130_fd_pr__pfet_01v8_hvt ad=0.135 pd=1.27 as=0.135 ps=1.27 w=1 l=0.15
X6 a_91_199# C_N VPWR VPB sky130_fd_pr__pfet_01v8_hvt ad=0.1092 pd=1.36 as=0.14575 ps=1.335 w=0.42 l=0.15
X7 a_161_297# a_91_199# Y VPB sky130_fd_pr__pfet_01v8_hvt ad=0.135 pd=1.27 as=0.32 ps=2.64 w=1 l=0.15
.ends

.subckt sky130_fd_sc_hd__nand3_1 VPB VNB VGND VPWR A B Y C
X0 VPWR B Y VPB sky130_fd_pr__pfet_01v8_hvt ad=0.165 pd=1.33 as=0.135 ps=1.27 w=1 l=0.15
X1 Y A VPWR VPB sky130_fd_pr__pfet_01v8_hvt ad=0.26 pd=2.52 as=0.165 ps=1.33 w=1 l=0.15
X2 a_193_47# B a_109_47# VNB sky130_fd_pr__nfet_01v8 ad=0.10725 pd=0.98 as=0.08775 ps=0.92 w=0.65 l=0.15
X3 Y A a_193_47# VNB sky130_fd_pr__nfet_01v8 ad=0.169 pd=1.82 as=0.10725 ps=0.98 w=0.65 l=0.15
X4 Y C VPWR VPB sky130_fd_pr__pfet_01v8_hvt ad=0.135 pd=1.27 as=0.26 ps=2.52 w=1 l=0.15
X5 a_109_47# C VGND VNB sky130_fd_pr__nfet_01v8 ad=0.08775 pd=0.92 as=0.169 ps=1.82 w=0.65 l=0.15
.ends

.subckt sky130_fd_sc_hd__and2_0 VNB VPB VPWR VGND X B A
X0 VPWR B a_40_47# VPB sky130_fd_pr__pfet_01v8_hvt ad=0.1841 pd=1.26 as=0.0609 ps=0.71 w=0.42 l=0.15
X1 X a_40_47# VPWR VPB sky130_fd_pr__pfet_01v8_hvt ad=0.1696 pd=1.81 as=0.1841 ps=1.26 w=0.64 l=0.15
X2 VGND B a_123_47# VNB sky130_fd_pr__nfet_01v8 ad=0.0966 pd=0.88 as=0.0441 ps=0.63 w=0.42 l=0.15
X3 X a_40_47# VGND VNB sky130_fd_pr__nfet_01v8 ad=0.1113 pd=1.37 as=0.0966 ps=0.88 w=0.42 l=0.15
X4 a_123_47# A a_40_47# VNB sky130_fd_pr__nfet_01v8 ad=0.0441 pd=0.63 as=0.1113 ps=1.37 w=0.42 l=0.15
X5 a_40_47# A VPWR VPB sky130_fd_pr__pfet_01v8_hvt ad=0.0609 pd=0.71 as=0.1113 ps=1.37 w=0.42 l=0.15
.ends

.subckt sky130_fd_sc_hd__a22oi_1 VPWR VGND VPB VNB B2 B1 Y A1 A2
X0 Y B1 a_109_47# VNB sky130_fd_pr__nfet_01v8 ad=0.169 pd=1.82 as=0.07475 ps=0.88 w=0.65 l=0.15
X1 Y B1 a_109_297# VPB sky130_fd_pr__pfet_01v8_hvt ad=0.26 pd=2.52 as=0.135 ps=1.27 w=1 l=0.15
X2 VPWR A2 a_109_297# VPB sky130_fd_pr__pfet_01v8_hvt ad=0.3 pd=2.6 as=0.135 ps=1.27 w=1 l=0.15
X3 a_109_297# A1 VPWR VPB sky130_fd_pr__pfet_01v8_hvt ad=0.135 pd=1.27 as=0.26 ps=2.52 w=1 l=0.15
X4 a_381_47# A1 Y VNB sky130_fd_pr__nfet_01v8 ad=0.06825 pd=0.86 as=0.169 ps=1.82 w=0.65 l=0.15
X5 a_109_297# B2 Y VPB sky130_fd_pr__pfet_01v8_hvt ad=0.135 pd=1.27 as=0.26 ps=2.52 w=1 l=0.15
X6 a_109_47# B2 VGND VNB sky130_fd_pr__nfet_01v8 ad=0.07475 pd=0.88 as=0.169 ps=1.82 w=0.65 l=0.15
X7 VGND A2 a_381_47# VNB sky130_fd_pr__nfet_01v8 ad=0.234 pd=2.02 as=0.06825 ps=0.86 w=0.65 l=0.15
.ends

.subckt sky130_fd_sc_hd__nor3_1 VPB VNB VGND VPWR C B A Y
X0 VPWR A a_193_297# VPB sky130_fd_pr__pfet_01v8_hvt ad=0.26 pd=2.52 as=0.135 ps=1.27 w=1 l=0.15
X1 a_193_297# B a_109_297# VPB sky130_fd_pr__pfet_01v8_hvt ad=0.135 pd=1.27 as=0.135 ps=1.27 w=1 l=0.15
X2 Y B VGND VNB sky130_fd_pr__nfet_01v8 ad=0.08775 pd=0.92 as=0.08775 ps=0.92 w=0.65 l=0.15
X3 VGND A Y VNB sky130_fd_pr__nfet_01v8 ad=0.169 pd=1.82 as=0.08775 ps=0.92 w=0.65 l=0.15
X4 a_109_297# C Y VPB sky130_fd_pr__pfet_01v8_hvt ad=0.135 pd=1.27 as=0.26 ps=2.52 w=1 l=0.15
X5 VGND C Y VNB sky130_fd_pr__nfet_01v8 ad=0.08775 pd=0.92 as=0.169 ps=1.82 w=0.65 l=0.15
.ends

.subckt sky130_fd_sc_hd__clkinv_1 VPB VNB VGND VPWR A Y
X0 Y A VPWR VPB sky130_fd_pr__pfet_01v8_hvt ad=0.1134 pd=1.11 as=0.2184 ps=2.2 w=0.84 l=0.15
X1 VGND A Y VNB sky130_fd_pr__nfet_01v8 ad=0.1197 pd=1.41 as=0.1092 ps=1.36 w=0.42 l=0.15
X2 VPWR A Y VPB sky130_fd_pr__pfet_01v8_hvt ad=0.2352 pd=2.24 as=0.1134 ps=1.11 w=0.84 l=0.15
.ends

.subckt sky130_fd_sc_hd__nand2b_1 VPB VNB VGND VPWR A_N B Y
X0 VGND A_N a_27_93# VNB sky130_fd_pr__nfet_01v8 ad=0.10025 pd=0.985 as=0.1092 ps=1.36 w=0.42 l=0.15
X1 Y a_27_93# a_206_47# VNB sky130_fd_pr__nfet_01v8 ad=0.169 pd=1.82 as=0.08775 ps=0.92 w=0.65 l=0.15
X2 a_206_47# B VGND VNB sky130_fd_pr__nfet_01v8 ad=0.08775 pd=0.92 as=0.10025 ps=0.985 w=0.65 l=0.15
X3 VPWR a_27_93# Y VPB sky130_fd_pr__pfet_01v8_hvt ad=0.265 pd=2.53 as=0.135 ps=1.27 w=1 l=0.15
X4 Y B VPWR VPB sky130_fd_pr__pfet_01v8_hvt ad=0.135 pd=1.27 as=0.14575 ps=1.335 w=1 l=0.15
X5 VPWR A_N a_27_93# VPB sky130_fd_pr__pfet_01v8_hvt ad=0.14575 pd=1.335 as=0.1092 ps=1.36 w=0.42 l=0.15
.ends

.subckt sky130_fd_sc_hd__a32o_1 VGND VPWR VPB VNB X A3 A2 A1 B1 B2
X0 a_93_21# A1 a_346_47# VNB sky130_fd_pr__nfet_01v8 ad=0.143 pd=1.09 as=0.14625 ps=1.1 w=0.65 l=0.15
X1 a_93_21# B1 a_250_297# VPB sky130_fd_pr__pfet_01v8_hvt ad=0.14 pd=1.28 as=0.185 ps=1.37 w=1 l=0.15
X2 a_584_47# B1 a_93_21# VNB sky130_fd_pr__nfet_01v8 ad=0.06825 pd=0.86 as=0.143 ps=1.09 w=0.65 l=0.15
X3 VPWR a_93_21# X VPB sky130_fd_pr__pfet_01v8_hvt ad=0.2425 pd=1.485 as=0.33 ps=2.66 w=1 l=0.15
X4 VGND B2 a_584_47# VNB sky130_fd_pr__nfet_01v8 ad=0.17225 pd=1.83 as=0.06825 ps=0.86 w=0.65 l=0.15
X5 a_256_47# A3 VGND VNB sky130_fd_pr__nfet_01v8 ad=0.0975 pd=0.95 as=0.16737 ps=1.165 w=0.65 l=0.15
X6 a_250_297# B2 a_93_21# VPB sky130_fd_pr__pfet_01v8_hvt ad=0.265 pd=2.53 as=0.14 ps=1.28 w=1 l=0.15
X7 VGND a_93_21# X VNB sky130_fd_pr__nfet_01v8 ad=0.16737 pd=1.165 as=0.2145 ps=1.96 w=0.65 l=0.15
X8 a_250_297# A3 VPWR VPB sky130_fd_pr__pfet_01v8_hvt ad=0.165 pd=1.33 as=0.2425 ps=1.485 w=1 l=0.15
X9 VPWR A2 a_250_297# VPB sky130_fd_pr__pfet_01v8_hvt ad=0.225 pd=1.45 as=0.165 ps=1.33 w=1 l=0.15
X10 a_250_297# A1 VPWR VPB sky130_fd_pr__pfet_01v8_hvt ad=0.185 pd=1.37 as=0.225 ps=1.45 w=1 l=0.15
X11 a_346_47# A2 a_256_47# VNB sky130_fd_pr__nfet_01v8 ad=0.14625 pd=1.1 as=0.0975 ps=0.95 w=0.65 l=0.15
.ends

.subckt sky130_fd_sc_hd__lpflow_inputiso1p_1 VPB VNB VGND VPWR X SLEEP A
X0 VGND SLEEP a_68_297# VNB sky130_fd_pr__nfet_01v8 ad=0.10025 pd=0.985 as=0.0567 ps=0.69 w=0.42 l=0.15
X1 a_68_297# A VGND VNB sky130_fd_pr__nfet_01v8 ad=0.0567 pd=0.69 as=0.1092 ps=1.36 w=0.42 l=0.15
X2 X a_68_297# VGND VNB sky130_fd_pr__nfet_01v8 ad=0.169 pd=1.82 as=0.10025 ps=0.985 w=0.65 l=0.15
X3 VPWR SLEEP a_150_297# VPB sky130_fd_pr__pfet_01v8_hvt ad=0.14575 pd=1.335 as=0.0441 ps=0.63 w=0.42 l=0.15
X4 X a_68_297# VPWR VPB sky130_fd_pr__pfet_01v8_hvt ad=0.34 pd=2.68 as=0.14575 ps=1.335 w=1 l=0.15
X5 a_150_297# A a_68_297# VPB sky130_fd_pr__pfet_01v8_hvt ad=0.0441 pd=0.63 as=0.1092 ps=1.36 w=0.42 l=0.15
.ends

.subckt sky130_fd_sc_hd__a2111oi_0 VNB VPB VPWR VGND D1 C1 A2 A1 B1 Y
X0 Y B1 VGND VNB sky130_fd_pr__nfet_01v8 ad=0.0588 pd=0.7 as=0.0735 ps=0.77 w=0.42 l=0.15
X1 VPWR A1 a_313_369# VPB sky130_fd_pr__pfet_01v8_hvt ad=0.1216 pd=1.02 as=0.0896 ps=0.92 w=0.64 l=0.15
X2 a_427_47# A1 Y VNB sky130_fd_pr__nfet_01v8 ad=0.0441 pd=0.63 as=0.0588 ps=0.7 w=0.42 l=0.15
X3 a_241_369# C1 a_169_369# VPB sky130_fd_pr__pfet_01v8_hvt ad=0.0672 pd=0.85 as=0.0672 ps=0.85 w=0.64 l=0.15
X4 VGND C1 Y VNB sky130_fd_pr__nfet_01v8 ad=0.0735 pd=0.77 as=0.0588 ps=0.7 w=0.42 l=0.15
X5 VGND A2 a_427_47# VNB sky130_fd_pr__nfet_01v8 ad=0.1197 pd=1.41 as=0.0441 ps=0.63 w=0.42 l=0.15
X6 a_169_369# D1 Y VPB sky130_fd_pr__pfet_01v8_hvt ad=0.0672 pd=0.85 as=0.1888 ps=1.87 w=0.64 l=0.15
X7 Y D1 VGND VNB sky130_fd_pr__nfet_01v8 ad=0.0588 pd=0.7 as=0.126 ps=1.44 w=0.42 l=0.15
X8 a_313_369# B1 a_241_369# VPB sky130_fd_pr__pfet_01v8_hvt ad=0.0896 pd=0.92 as=0.0672 ps=0.85 w=0.64 l=0.15
X9 a_313_369# A2 VPWR VPB sky130_fd_pr__pfet_01v8_hvt ad=0.1952 pd=1.89 as=0.1216 ps=1.02 w=0.64 l=0.15
.ends

.subckt sky130_fd_sc_hd__a221oi_1 VGND VPWR VPB VNB Y B1 C1 A1 A2 B2
X0 a_465_47# A1 Y VNB sky130_fd_pr__nfet_01v8 ad=0.09912 pd=0.955 as=0.169 ps=1.82 w=0.65 l=0.15
X1 a_109_297# B1 a_193_297# VPB sky130_fd_pr__pfet_01v8_hvt ad=0.26 pd=2.52 as=0.135 ps=1.27 w=1 l=0.15
X2 a_193_297# B2 a_109_297# VPB sky130_fd_pr__pfet_01v8_hvt ad=0.135 pd=1.27 as=0.135 ps=1.27 w=1 l=0.15
X3 a_204_47# B2 VGND VNB sky130_fd_pr__nfet_01v8 ad=0.06988 pd=0.865 as=0.10563 ps=0.975 w=0.65 l=0.15
X4 VGND A2 a_465_47# VNB sky130_fd_pr__nfet_01v8 ad=0.19825 pd=1.91 as=0.09912 ps=0.955 w=0.65 l=0.15
X5 a_193_297# A1 VPWR VPB sky130_fd_pr__pfet_01v8_hvt ad=0.1525 pd=1.305 as=0.26 ps=2.52 w=1 l=0.15
X6 Y B1 a_204_47# VNB sky130_fd_pr__nfet_01v8 ad=0.169 pd=1.82 as=0.06988 ps=0.865 w=0.65 l=0.15
X7 VPWR A2 a_193_297# VPB sky130_fd_pr__pfet_01v8_hvt ad=0.305 pd=2.61 as=0.1525 ps=1.305 w=1 l=0.15
X8 a_109_297# C1 Y VPB sky130_fd_pr__pfet_01v8_hvt ad=0.135 pd=1.27 as=0.26 ps=2.52 w=1 l=0.15
X9 VGND C1 Y VNB sky130_fd_pr__nfet_01v8 ad=0.10563 pd=0.975 as=0.169 ps=1.82 w=0.65 l=0.15
.ends

.subckt sky130_fd_sc_hd__dfstp_2 VPB VNB VPWR VGND Q SET_B D CLK
X0 VGND a_652_21# a_586_47# VNB sky130_fd_pr__nfet_01v8 ad=0.0882 pd=0.84 as=0.06705 ps=0.75 w=0.42 l=0.15
X1 a_956_413# a_476_47# VPWR VPB sky130_fd_pr__pfet_01v8_hvt ad=0.0441 pd=0.63 as=0.0567 ps=0.69 w=0.42 l=0.15
X2 a_1136_413# a_193_47# a_1028_413# VPB sky130_fd_pr__pfet_01v8_hvt ad=0.0441 pd=0.63 as=0.0819 ps=0.81 w=0.42 l=0.15
X3 VPWR a_476_47# a_652_21# VPB sky130_fd_pr__pfet_01v8_hvt ad=0.0567 pd=0.69 as=0.0567 ps=0.69 w=0.42 l=0.15
X4 a_586_47# a_193_47# a_476_47# VNB sky130_fd_pr__nfet_01v8 ad=0.06705 pd=0.75 as=0.072 ps=0.76 w=0.36 l=0.15
X5 a_1228_47# a_27_47# a_1028_413# VNB sky130_fd_pr__nfet_01v8 ad=0.0441 pd=0.63 as=0.0735 ps=0.77 w=0.42 l=0.15
X6 VPWR CLK a_27_47# VPB sky130_fd_pr__pfet_01v8_hvt ad=0.0864 pd=0.91 as=0.1664 ps=1.8 w=0.64 l=0.15
X7 a_476_47# a_27_47# a_381_47# VNB sky130_fd_pr__nfet_01v8 ad=0.072 pd=0.76 as=0.0935 ps=0.965 w=0.36 l=0.15
X8 a_1056_47# a_476_47# VGND VNB sky130_fd_pr__nfet_01v8 ad=0.0441 pd=0.63 as=0.1092 ps=1.36 w=0.42 l=0.15
X9 a_381_47# D VPWR VPB sky130_fd_pr__pfet_01v8_hvt ad=0.12495 pd=1.175 as=0.2184 ps=2.2 w=0.84 l=0.15
X10 a_652_21# SET_B VPWR VPB sky130_fd_pr__pfet_01v8_hvt ad=0.0567 pd=0.69 as=0.0798 ps=0.8 w=0.42 l=0.15
X11 VPWR a_1602_47# Q VPB sky130_fd_pr__pfet_01v8_hvt ad=0.26 pd=2.52 as=0.135 ps=1.27 w=1 l=0.15
X12 a_562_413# a_27_47# a_476_47# VPB sky130_fd_pr__pfet_01v8_hvt ad=0.0945 pd=0.87 as=0.0567 ps=0.69 w=0.42 l=0.15
X13 VGND a_1028_413# a_1602_47# VNB sky130_fd_pr__nfet_01v8 ad=0.08775 pd=0.92 as=0.169 ps=1.82 w=0.65 l=0.15
X14 VGND a_1602_47# Q VNB sky130_fd_pr__nfet_01v8 ad=0.169 pd=1.82 as=0.08775 ps=0.92 w=0.65 l=0.15
X15 Q a_1602_47# VPWR VPB sky130_fd_pr__pfet_01v8_hvt ad=0.135 pd=1.27 as=0.135 ps=1.27 w=1 l=0.15
X16 a_1028_413# a_193_47# a_1056_47# VNB sky130_fd_pr__nfet_01v8 ad=0.0735 pd=0.77 as=0.0441 ps=0.63 w=0.42 l=0.15
X17 a_476_47# a_193_47# a_381_47# VPB sky130_fd_pr__pfet_01v8_hvt ad=0.0567 pd=0.69 as=0.12495 ps=1.175 w=0.42 l=0.15
X18 a_193_47# a_27_47# VGND VNB sky130_fd_pr__nfet_01v8 ad=0.1092 pd=1.36 as=0.0567 ps=0.69 w=0.42 l=0.15
X19 VPWR a_1028_413# a_1602_47# VPB sky130_fd_pr__pfet_01v8_hvt ad=0.135 pd=1.27 as=0.26 ps=2.52 w=1 l=0.15
X20 VPWR a_652_21# a_562_413# VPB sky130_fd_pr__pfet_01v8_hvt ad=0.0798 pd=0.8 as=0.0945 ps=0.87 w=0.42 l=0.15
X21 Q a_1602_47# VGND VNB sky130_fd_pr__nfet_01v8 ad=0.08775 pd=0.92 as=0.08775 ps=0.92 w=0.65 l=0.15
X22 a_1028_413# a_27_47# a_956_413# VPB sky130_fd_pr__pfet_01v8_hvt ad=0.0819 pd=0.81 as=0.0441 ps=0.63 w=0.42 l=0.15
X23 VPWR a_1178_261# a_1136_413# VPB sky130_fd_pr__pfet_01v8_hvt ad=0.1092 pd=1.36 as=0.0441 ps=0.63 w=0.42 l=0.15
X24 a_193_47# a_27_47# VPWR VPB sky130_fd_pr__pfet_01v8_hvt ad=0.1664 pd=1.8 as=0.0864 ps=0.91 w=0.64 l=0.15
X25 a_1178_261# a_1028_413# VPWR VPB sky130_fd_pr__pfet_01v8_hvt ad=0.2226 pd=2.21 as=0.12075 ps=1.165 w=0.84 l=0.15
X26 a_796_47# SET_B VGND VNB sky130_fd_pr__nfet_01v8 ad=0.0441 pd=0.63 as=0.0882 ps=0.84 w=0.42 l=0.15
X27 a_1300_47# a_1178_261# a_1228_47# VNB sky130_fd_pr__nfet_01v8 ad=0.0441 pd=0.63 as=0.0441 ps=0.63 w=0.42 l=0.15
X28 a_381_47# D VGND VNB sky130_fd_pr__nfet_01v8 ad=0.0935 pd=0.965 as=0.1664 ps=1.8 w=0.64 l=0.15
X29 a_1178_261# a_1028_413# VGND VNB sky130_fd_pr__nfet_01v8 ad=0.1404 pd=1.6 as=0.1137 ps=1.01 w=0.54 l=0.15
X30 a_652_21# a_476_47# a_796_47# VNB sky130_fd_pr__nfet_01v8 ad=0.1092 pd=1.36 as=0.0441 ps=0.63 w=0.42 l=0.15
X31 VPWR SET_B a_1028_413# VPB sky130_fd_pr__pfet_01v8_hvt ad=0.12075 pd=1.165 as=0.1092 ps=1.36 w=0.42 l=0.15
X32 VGND CLK a_27_47# VNB sky130_fd_pr__nfet_01v8 ad=0.0567 pd=0.69 as=0.1092 ps=1.36 w=0.42 l=0.15
X33 VGND SET_B a_1300_47# VNB sky130_fd_pr__nfet_01v8 ad=0.1137 pd=1.01 as=0.0441 ps=0.63 w=0.42 l=0.15
.ends

.subckt sky130_fd_sc_hd__a21oi_1 VPWR VGND VPB VNB A2 A1 B1 Y
X0 a_199_47# A1 Y VNB sky130_fd_pr__nfet_01v8 ad=0.09588 pd=0.945 as=0.091 ps=0.93 w=0.65 l=0.15
X1 a_113_297# A2 VPWR VPB sky130_fd_pr__pfet_01v8_hvt ad=0.265 pd=2.53 as=0.1475 ps=1.295 w=1 l=0.15
X2 Y B1 VGND VNB sky130_fd_pr__nfet_01v8 ad=0.091 pd=0.93 as=0.17225 ps=1.83 w=0.65 l=0.15
X3 VPWR A1 a_113_297# VPB sky130_fd_pr__pfet_01v8_hvt ad=0.1475 pd=1.295 as=0.14 ps=1.28 w=1 l=0.15
X4 a_113_297# B1 Y VPB sky130_fd_pr__pfet_01v8_hvt ad=0.14 pd=1.28 as=0.265 ps=2.53 w=1 l=0.15
X5 VGND A2 a_199_47# VNB sky130_fd_pr__nfet_01v8 ad=0.17225 pd=1.83 as=0.09588 ps=0.945 w=0.65 l=0.15
.ends

.subckt sky130_fd_sc_hd__decap_3 VPWR VGND VPB VNB
X0 VPWR VGND VPWR VPB sky130_fd_pr__pfet_01v8_hvt ad=0.2262 pd=2.26 as=0.4524 ps=4.52 w=0.87 l=0.59
X1 VGND VPWR VGND VNB sky130_fd_pr__nfet_01v8 ad=0.143 pd=1.62 as=0.286 ps=3.24 w=0.55 l=0.59
.ends

.subckt sky130_fd_sc_hd__or3_1 VPWR VGND VPB VNB B C A X
X0 X a_29_53# VPWR VPB sky130_fd_pr__pfet_01v8_hvt ad=0.28 pd=2.56 as=0.14825 ps=1.34 w=1 l=0.15
X1 a_111_297# C a_29_53# VPB sky130_fd_pr__pfet_01v8_hvt ad=0.0441 pd=0.63 as=0.1092 ps=1.36 w=0.42 l=0.15
X2 X a_29_53# VGND VNB sky130_fd_pr__nfet_01v8 ad=0.182 pd=1.86 as=0.10187 ps=0.99 w=0.65 l=0.15
X3 a_183_297# B a_111_297# VPB sky130_fd_pr__pfet_01v8_hvt ad=0.0693 pd=0.75 as=0.0441 ps=0.63 w=0.42 l=0.15
X4 VPWR A a_183_297# VPB sky130_fd_pr__pfet_01v8_hvt ad=0.14825 pd=1.34 as=0.0693 ps=0.75 w=0.42 l=0.15
X5 a_29_53# B VGND VNB sky130_fd_pr__nfet_01v8 ad=0.0567 pd=0.69 as=0.0567 ps=0.69 w=0.42 l=0.15
X6 VGND C a_29_53# VNB sky130_fd_pr__nfet_01v8 ad=0.0567 pd=0.69 as=0.1092 ps=1.36 w=0.42 l=0.15
X7 VGND A a_29_53# VNB sky130_fd_pr__nfet_01v8 ad=0.10187 pd=0.99 as=0.0567 ps=0.69 w=0.42 l=0.15
.ends

.subckt sky130_fd_sc_hd__a211o_1 VNB VPB VGND VPWR X A2 B1 A1 C1
X0 VPWR a_80_21# X VPB sky130_fd_pr__pfet_01v8_hvt ad=0.265 pd=2.53 as=0.265 ps=2.53 w=1 l=0.15
X1 a_80_21# C1 a_472_297# VPB sky130_fd_pr__pfet_01v8_hvt ad=0.265 pd=2.53 as=0.155 ps=1.31 w=1 l=0.15
X2 VPWR A2 a_217_297# VPB sky130_fd_pr__pfet_01v8_hvt ad=0.14 pd=1.28 as=0.265 ps=2.53 w=1 l=0.15
X3 VGND B1 a_80_21# VNB sky130_fd_pr__nfet_01v8 ad=0.10075 pd=0.96 as=0.091 ps=0.93 w=0.65 l=0.15
X4 VGND a_80_21# X VNB sky130_fd_pr__nfet_01v8 ad=0.26 pd=1.45 as=0.17225 ps=1.83 w=0.65 l=0.15
X5 a_300_47# A2 VGND VNB sky130_fd_pr__nfet_01v8 ad=0.091 pd=0.93 as=0.26 ps=1.45 w=0.65 l=0.15
X6 a_217_297# A1 VPWR VPB sky130_fd_pr__pfet_01v8_hvt ad=0.14 pd=1.28 as=0.14 ps=1.28 w=1 l=0.15
X7 a_80_21# A1 a_300_47# VNB sky130_fd_pr__nfet_01v8 ad=0.091 pd=0.93 as=0.091 ps=0.93 w=0.65 l=0.15
X8 a_472_297# B1 a_217_297# VPB sky130_fd_pr__pfet_01v8_hvt ad=0.155 pd=1.31 as=0.14 ps=1.28 w=1 l=0.15
X9 a_80_21# C1 VGND VNB sky130_fd_pr__nfet_01v8 ad=0.17225 pd=1.83 as=0.10075 ps=0.96 w=0.65 l=0.15
.ends

.subckt sky130_fd_sc_hd__clkbuf_16 VNB VPB VGND VPWR A X
X0 VPWR A a_110_47# VPB sky130_fd_pr__pfet_01v8_hvt ad=0.14 pd=1.28 as=0.14 ps=1.28 w=1 l=0.15
X1 VPWR a_110_47# X VPB sky130_fd_pr__pfet_01v8_hvt ad=0.14 pd=1.28 as=0.14 ps=1.28 w=1 l=0.15
X2 X a_110_47# VPWR VPB sky130_fd_pr__pfet_01v8_hvt ad=0.14 pd=1.28 as=0.14 ps=1.28 w=1 l=0.15
X3 X a_110_47# VPWR VPB sky130_fd_pr__pfet_01v8_hvt ad=0.14 pd=1.28 as=0.14 ps=1.28 w=1 l=0.15
X4 VPWR a_110_47# X VPB sky130_fd_pr__pfet_01v8_hvt ad=0.14 pd=1.28 as=0.14 ps=1.28 w=1 l=0.15
X5 VPWR a_110_47# X VPB sky130_fd_pr__pfet_01v8_hvt ad=0.265 pd=2.53 as=0.14 ps=1.28 w=1 l=0.15
X6 a_110_47# A VPWR VPB sky130_fd_pr__pfet_01v8_hvt ad=0.14 pd=1.28 as=0.265 ps=2.53 w=1 l=0.15
X7 a_110_47# A VGND VNB sky130_fd_pr__nfet_01v8 ad=0.0588 pd=0.7 as=0.0588 ps=0.7 w=0.42 l=0.15
X8 VGND a_110_47# X VNB sky130_fd_pr__nfet_01v8 ad=0.0588 pd=0.7 as=0.0588 ps=0.7 w=0.42 l=0.15
X9 X a_110_47# VGND VNB sky130_fd_pr__nfet_01v8 ad=0.0588 pd=0.7 as=0.0588 ps=0.7 w=0.42 l=0.15
X10 VGND a_110_47# X VNB sky130_fd_pr__nfet_01v8 ad=0.0588 pd=0.7 as=0.0588 ps=0.7 w=0.42 l=0.15
X11 a_110_47# A VPWR VPB sky130_fd_pr__pfet_01v8_hvt ad=0.14 pd=1.28 as=0.14 ps=1.28 w=1 l=0.15
X12 VGND A a_110_47# VNB sky130_fd_pr__nfet_01v8 ad=0.0588 pd=0.7 as=0.0588 ps=0.7 w=0.42 l=0.15
X13 VGND a_110_47# X VNB sky130_fd_pr__nfet_01v8 ad=0.05775 pd=0.695 as=0.0588 ps=0.7 w=0.42 l=0.15
X14 VPWR a_110_47# X VPB sky130_fd_pr__pfet_01v8_hvt ad=0.14 pd=1.28 as=0.14 ps=1.28 w=1 l=0.15
X15 X a_110_47# VPWR VPB sky130_fd_pr__pfet_01v8_hvt ad=0.14 pd=1.28 as=0.14 ps=1.28 w=1 l=0.15
X16 VGND A a_110_47# VNB sky130_fd_pr__nfet_01v8 ad=0.0588 pd=0.7 as=0.0588 ps=0.7 w=0.42 l=0.15
X17 VGND a_110_47# X VNB sky130_fd_pr__nfet_01v8 ad=0.1113 pd=1.37 as=0.0588 ps=0.7 w=0.42 l=0.15
X18 VPWR a_110_47# X VPB sky130_fd_pr__pfet_01v8_hvt ad=0.1375 pd=1.275 as=0.14 ps=1.28 w=1 l=0.15
X19 VGND a_110_47# X VNB sky130_fd_pr__nfet_01v8 ad=0.0588 pd=0.7 as=0.0588 ps=0.7 w=0.42 l=0.15
X20 X a_110_47# VPWR VPB sky130_fd_pr__pfet_01v8_hvt ad=0.14 pd=1.28 as=0.1375 ps=1.275 w=1 l=0.15
X21 a_110_47# A VGND VNB sky130_fd_pr__nfet_01v8 ad=0.0588 pd=0.7 as=0.1113 ps=1.37 w=0.42 l=0.15
X22 VPWR A a_110_47# VPB sky130_fd_pr__pfet_01v8_hvt ad=0.14 pd=1.28 as=0.14 ps=1.28 w=1 l=0.15
X23 VPWR a_110_47# X VPB sky130_fd_pr__pfet_01v8_hvt ad=0.14 pd=1.28 as=0.14 ps=1.28 w=1 l=0.15
X24 VPWR a_110_47# X VPB sky130_fd_pr__pfet_01v8_hvt ad=0.14 pd=1.28 as=0.14 ps=1.28 w=1 l=0.15
X25 VGND a_110_47# X VNB sky130_fd_pr__nfet_01v8 ad=0.0588 pd=0.7 as=0.0588 ps=0.7 w=0.42 l=0.15
X26 X a_110_47# VPWR VPB sky130_fd_pr__pfet_01v8_hvt ad=0.14 pd=1.28 as=0.14 ps=1.28 w=1 l=0.15
X27 VGND a_110_47# X VNB sky130_fd_pr__nfet_01v8 ad=0.0588 pd=0.7 as=0.0588 ps=0.7 w=0.42 l=0.15
X28 VGND a_110_47# X VNB sky130_fd_pr__nfet_01v8 ad=0.0588 pd=0.7 as=0.0588 ps=0.7 w=0.42 l=0.15
X29 X a_110_47# VGND VNB sky130_fd_pr__nfet_01v8 ad=0.0588 pd=0.7 as=0.0588 ps=0.7 w=0.42 l=0.15
X30 X a_110_47# VPWR VPB sky130_fd_pr__pfet_01v8_hvt ad=0.14 pd=1.28 as=0.14 ps=1.28 w=1 l=0.15
X31 X a_110_47# VPWR VPB sky130_fd_pr__pfet_01v8_hvt ad=0.14 pd=1.28 as=0.14 ps=1.28 w=1 l=0.15
X32 X a_110_47# VGND VNB sky130_fd_pr__nfet_01v8 ad=0.0588 pd=0.7 as=0.0588 ps=0.7 w=0.42 l=0.15
X33 VPWR a_110_47# X VPB sky130_fd_pr__pfet_01v8_hvt ad=0.14 pd=1.28 as=0.14 ps=1.28 w=1 l=0.15
X34 X a_110_47# VPWR VPB sky130_fd_pr__pfet_01v8_hvt ad=0.14 pd=1.28 as=0.14 ps=1.28 w=1 l=0.15
X35 X a_110_47# VGND VNB sky130_fd_pr__nfet_01v8 ad=0.0588 pd=0.7 as=0.0588 ps=0.7 w=0.42 l=0.15
X36 X a_110_47# VGND VNB sky130_fd_pr__nfet_01v8 ad=0.0588 pd=0.7 as=0.0588 ps=0.7 w=0.42 l=0.15
X37 X a_110_47# VGND VNB sky130_fd_pr__nfet_01v8 ad=0.0588 pd=0.7 as=0.0588 ps=0.7 w=0.42 l=0.15
X38 X a_110_47# VGND VNB sky130_fd_pr__nfet_01v8 ad=0.0588 pd=0.7 as=0.0588 ps=0.7 w=0.42 l=0.15
X39 X a_110_47# VGND VNB sky130_fd_pr__nfet_01v8 ad=0.0588 pd=0.7 as=0.05775 ps=0.695 w=0.42 l=0.15
.ends

.subckt sky130_fd_sc_hd__o32ai_1 VPB VNB VGND VPWR A1 A2 B1 Y B2 A3
X0 VGND A3 a_27_47# VNB sky130_fd_pr__nfet_01v8 ad=0.21937 pd=1.325 as=0.10075 ps=0.96 w=0.65 l=0.15
X1 a_27_47# A2 VGND VNB sky130_fd_pr__nfet_01v8 ad=0.08775 pd=0.92 as=0.21937 ps=1.325 w=0.65 l=0.15
X2 Y B2 a_109_297# VPB sky130_fd_pr__pfet_01v8_hvt ad=0.305 pd=1.61 as=0.105 ps=1.21 w=1 l=0.15
X3 a_333_297# A3 Y VPB sky130_fd_pr__pfet_01v8_hvt ad=0.245 pd=1.49 as=0.305 ps=1.61 w=1 l=0.15
X4 VGND A1 a_27_47# VNB sky130_fd_pr__nfet_01v8 ad=0.234 pd=2.02 as=0.08775 ps=0.92 w=0.65 l=0.15
X5 a_27_47# B2 Y VNB sky130_fd_pr__nfet_01v8 ad=0.10075 pd=0.96 as=0.10563 ps=0.975 w=0.65 l=0.15
X6 VPWR A1 a_461_297# VPB sky130_fd_pr__pfet_01v8_hvt ad=0.28 pd=2.56 as=0.135 ps=1.27 w=1 l=0.15
X7 a_109_297# B1 VPWR VPB sky130_fd_pr__pfet_01v8_hvt ad=0.105 pd=1.21 as=0.26 ps=2.52 w=1 l=0.15
X8 a_461_297# A2 a_333_297# VPB sky130_fd_pr__pfet_01v8_hvt ad=0.135 pd=1.27 as=0.245 ps=1.49 w=1 l=0.15
X9 Y B1 a_27_47# VNB sky130_fd_pr__nfet_01v8 ad=0.10563 pd=0.975 as=0.169 ps=1.82 w=0.65 l=0.15
.ends

.subckt sky130_fd_sc_hd__o22ai_1 VPB VNB VGND VPWR A1 A2 B1 B2 Y
X0 VGND A2 a_27_47# VNB sky130_fd_pr__nfet_01v8 ad=0.08775 pd=0.92 as=0.11537 ps=1.005 w=0.65 l=0.15
X1 a_27_47# B2 Y VNB sky130_fd_pr__nfet_01v8 ad=0.11537 pd=1.005 as=0.09262 ps=0.935 w=0.65 l=0.15
X2 VPWR A1 a_307_297# VPB sky130_fd_pr__pfet_01v8_hvt ad=0.27 pd=2.54 as=0.105 ps=1.21 w=1 l=0.15
X3 a_307_297# A2 Y VPB sky130_fd_pr__pfet_01v8_hvt ad=0.105 pd=1.21 as=0.2325 ps=1.465 w=1 l=0.15
X4 a_27_47# A1 VGND VNB sky130_fd_pr__nfet_01v8 ad=0.169 pd=1.82 as=0.08775 ps=0.92 w=0.65 l=0.15
X5 Y B2 a_109_297# VPB sky130_fd_pr__pfet_01v8_hvt ad=0.2325 pd=1.465 as=0.1125 ps=1.225 w=1 l=0.15
X6 a_109_297# B1 VPWR VPB sky130_fd_pr__pfet_01v8_hvt ad=0.1125 pd=1.225 as=0.26 ps=2.52 w=1 l=0.15
X7 Y B1 a_27_47# VNB sky130_fd_pr__nfet_01v8 ad=0.09262 pd=0.935 as=0.169 ps=1.82 w=0.65 l=0.15
.ends

.subckt sky130_fd_sc_hd__o31ai_1 VPB VNB A1 A2 A3 Y B1 VPWR VGND
X0 Y B1 a_109_47# VNB sky130_fd_pr__nfet_01v8 ad=0.221 pd=1.98 as=0.19825 ps=1.26 w=0.65 l=0.15
X1 Y A3 a_193_297# VPB sky130_fd_pr__pfet_01v8_hvt ad=0.3925 pd=1.785 as=0.135 ps=1.27 w=1 l=0.15
X2 a_193_297# A2 a_109_297# VPB sky130_fd_pr__pfet_01v8_hvt ad=0.135 pd=1.27 as=0.135 ps=1.27 w=1 l=0.15
X3 VGND A2 a_109_47# VNB sky130_fd_pr__nfet_01v8 ad=0.08775 pd=0.92 as=0.08775 ps=0.92 w=0.65 l=0.15
X4 VPWR B1 Y VPB sky130_fd_pr__pfet_01v8_hvt ad=0.3 pd=2.6 as=0.3925 ps=1.785 w=1 l=0.15
X5 a_109_47# A3 VGND VNB sky130_fd_pr__nfet_01v8 ad=0.19825 pd=1.26 as=0.08775 ps=0.92 w=0.65 l=0.15
X6 a_109_297# A1 VPWR VPB sky130_fd_pr__pfet_01v8_hvt ad=0.135 pd=1.27 as=0.26 ps=2.52 w=1 l=0.15
X7 a_109_47# A1 VGND VNB sky130_fd_pr__nfet_01v8 ad=0.08775 pd=0.92 as=0.169 ps=1.82 w=0.65 l=0.15
.ends

.subckt sky130_fd_sc_hd__or4_1 VPWR VGND VPB VNB B D C A X
X0 a_27_297# B VGND VNB sky130_fd_pr__nfet_01v8 ad=0.0567 pd=0.69 as=0.0567 ps=0.69 w=0.42 l=0.15
X1 a_27_297# D VGND VNB sky130_fd_pr__nfet_01v8 ad=0.0693 pd=0.75 as=0.1092 ps=1.36 w=0.42 l=0.15
X2 a_277_297# B a_205_297# VPB sky130_fd_pr__pfet_01v8_hvt ad=0.0693 pd=0.75 as=0.0441 ps=0.63 w=0.42 l=0.15
X3 VPWR A a_277_297# VPB sky130_fd_pr__pfet_01v8_hvt ad=0.14825 pd=1.34 as=0.0693 ps=0.75 w=0.42 l=0.15
X4 X a_27_297# VGND VNB sky130_fd_pr__nfet_01v8 ad=0.1755 pd=1.84 as=0.10187 ps=0.99 w=0.65 l=0.15
X5 a_205_297# C a_109_297# VPB sky130_fd_pr__pfet_01v8_hvt ad=0.0441 pd=0.63 as=0.0693 ps=0.75 w=0.42 l=0.15
X6 X a_27_297# VPWR VPB sky130_fd_pr__pfet_01v8_hvt ad=0.27 pd=2.54 as=0.14825 ps=1.34 w=1 l=0.15
X7 VGND C a_27_297# VNB sky130_fd_pr__nfet_01v8 ad=0.0567 pd=0.69 as=0.0693 ps=0.75 w=0.42 l=0.15
X8 a_109_297# D a_27_297# VPB sky130_fd_pr__pfet_01v8_hvt ad=0.0693 pd=0.75 as=0.1092 ps=1.36 w=0.42 l=0.15
X9 VGND A a_27_297# VNB sky130_fd_pr__nfet_01v8 ad=0.10187 pd=0.99 as=0.0567 ps=0.69 w=0.42 l=0.15
.ends

.subckt sky130_fd_sc_hd__nand4b_1 VPB VNB VGND VPWR Y C B D A_N
X0 Y B VPWR VPB sky130_fd_pr__pfet_01v8_hvt ad=0.195 pd=1.39 as=0.1925 ps=1.385 w=1 l=0.15
X1 a_232_47# D VGND VNB sky130_fd_pr__nfet_01v8 ad=0.08775 pd=0.92 as=0.11812 ps=1.04 w=0.65 l=0.15
X2 VPWR C Y VPB sky130_fd_pr__pfet_01v8_hvt ad=0.1925 pd=1.385 as=0.135 ps=1.27 w=1 l=0.15
X3 VPWR A_N a_41_93# VPB sky130_fd_pr__pfet_01v8_hvt ad=0.14575 pd=1.335 as=0.1092 ps=1.36 w=0.42 l=0.15
X4 VPWR a_41_93# Y VPB sky130_fd_pr__pfet_01v8_hvt ad=0.28 pd=2.56 as=0.195 ps=1.39 w=1 l=0.15
X5 a_316_47# C a_232_47# VNB sky130_fd_pr__nfet_01v8 ad=0.12513 pd=1.035 as=0.08775 ps=0.92 w=0.65 l=0.15
X6 Y a_41_93# a_423_47# VNB sky130_fd_pr__nfet_01v8 ad=0.2275 pd=2 as=0.12675 ps=1.04 w=0.65 l=0.15
X7 a_423_47# B a_316_47# VNB sky130_fd_pr__nfet_01v8 ad=0.12675 pd=1.04 as=0.12513 ps=1.035 w=0.65 l=0.15
X8 Y D VPWR VPB sky130_fd_pr__pfet_01v8_hvt ad=0.135 pd=1.27 as=0.14575 ps=1.335 w=1 l=0.15
X9 VGND A_N a_41_93# VNB sky130_fd_pr__nfet_01v8 ad=0.11812 pd=1.04 as=0.1113 ps=1.37 w=0.42 l=0.15
.ends

.subckt sky130_fd_sc_hd__lpflow_isobufsrc_1 VPB VNB VGND VPWR A SLEEP X
X0 X a_74_47# a_265_297# VPB sky130_fd_pr__pfet_01v8_hvt ad=0.26 pd=2.52 as=0.105 ps=1.21 w=1 l=0.15
X1 VPWR A a_74_47# VPB sky130_fd_pr__pfet_01v8_hvt ad=0.1573 pd=1.39 as=0.1092 ps=1.36 w=0.42 l=0.15
X2 a_265_297# SLEEP VPWR VPB sky130_fd_pr__pfet_01v8_hvt ad=0.105 pd=1.21 as=0.1573 ps=1.39 w=1 l=0.15
X3 X SLEEP VGND VNB sky130_fd_pr__nfet_01v8 ad=0.08775 pd=0.92 as=0.10025 ps=0.985 w=0.65 l=0.15
X4 VGND A a_74_47# VNB sky130_fd_pr__nfet_01v8 ad=0.10025 pd=0.985 as=0.1092 ps=1.36 w=0.42 l=0.15
X5 VGND a_74_47# X VNB sky130_fd_pr__nfet_01v8 ad=0.169 pd=1.82 as=0.08775 ps=0.92 w=0.65 l=0.15
.ends

.subckt sky130_fd_sc_hd__xor2_1 VNB VPB VPWR VGND A X B
X0 X a_35_297# a_285_297# VPB sky130_fd_pr__pfet_01v8_hvt ad=0.3 pd=2.6 as=0.26 ps=2.52 w=1 l=0.15
X1 X B a_285_47# VNB sky130_fd_pr__nfet_01v8 ad=0.25025 pd=1.42 as=0.08775 ps=0.92 w=0.65 l=0.15
X2 a_35_297# B VGND VNB sky130_fd_pr__nfet_01v8 ad=0.08775 pd=0.92 as=0.169 ps=1.82 w=0.65 l=0.15
X3 a_117_297# B a_35_297# VPB sky130_fd_pr__pfet_01v8_hvt ad=0.135 pd=1.27 as=0.26 ps=2.52 w=1 l=0.15
X4 VPWR B a_285_297# VPB sky130_fd_pr__pfet_01v8_hvt ad=0.26 pd=2.52 as=0.135 ps=1.27 w=1 l=0.15
X5 VGND A a_35_297# VNB sky130_fd_pr__nfet_01v8 ad=0.08775 pd=0.92 as=0.08775 ps=0.92 w=0.65 l=0.15
X6 VGND a_35_297# X VNB sky130_fd_pr__nfet_01v8 ad=0.208 pd=1.94 as=0.25025 ps=1.42 w=0.65 l=0.15
X7 a_285_297# A VPWR VPB sky130_fd_pr__pfet_01v8_hvt ad=0.135 pd=1.27 as=0.135 ps=1.27 w=1 l=0.15
X8 VPWR A a_117_297# VPB sky130_fd_pr__pfet_01v8_hvt ad=0.135 pd=1.27 as=0.135 ps=1.27 w=1 l=0.15
X9 a_285_47# A VGND VNB sky130_fd_pr__nfet_01v8 ad=0.08775 pd=0.92 as=0.08775 ps=0.92 w=0.65 l=0.15
.ends

.subckt sky130_fd_sc_hd__conb_1 LO HI VPB VNB VGND VPWR
R0 VPWR HI sky130_fd_pr__res_generic_po w=0.48 l=0.045
R1 LO VGND sky130_fd_pr__res_generic_po w=0.48 l=0.045
.ends

.subckt sky130_fd_sc_hd__nor4_1 VPB VNB VGND VPWR Y D C B A
X0 Y B VGND VNB sky130_fd_pr__nfet_01v8 ad=0.08775 pd=0.92 as=0.08937 ps=0.925 w=0.65 l=0.15
X1 a_191_297# C a_109_297# VPB sky130_fd_pr__pfet_01v8_hvt ad=0.19 pd=1.38 as=0.13 ps=1.26 w=1 l=0.15
X2 VPWR A a_297_297# VPB sky130_fd_pr__pfet_01v8_hvt ad=0.26 pd=2.52 as=0.135 ps=1.27 w=1 l=0.15
X3 VGND C Y VNB sky130_fd_pr__nfet_01v8 ad=0.08937 pd=0.925 as=0.11863 ps=1.015 w=0.65 l=0.15
X4 VGND A Y VNB sky130_fd_pr__nfet_01v8 ad=0.169 pd=1.82 as=0.08775 ps=0.92 w=0.65 l=0.15
X5 a_297_297# B a_191_297# VPB sky130_fd_pr__pfet_01v8_hvt ad=0.135 pd=1.27 as=0.19 ps=1.38 w=1 l=0.15
X6 a_109_297# D Y VPB sky130_fd_pr__pfet_01v8_hvt ad=0.13 pd=1.26 as=0.26 ps=2.52 w=1 l=0.15
X7 Y D VGND VNB sky130_fd_pr__nfet_01v8 ad=0.11863 pd=1.015 as=0.169 ps=1.82 w=0.65 l=0.15
.ends

.subckt sky130_fd_sc_hd__a21o_1 VPWR VGND VPB VNB A2 A1 B1 X
X0 a_81_21# B1 VGND VNB sky130_fd_pr__nfet_01v8 ad=0.08937 pd=0.925 as=0.25675 ps=1.44 w=0.65 l=0.15
X1 a_299_297# B1 a_81_21# VPB sky130_fd_pr__pfet_01v8_hvt ad=0.1375 pd=1.275 as=0.26 ps=2.52 w=1 l=0.15
X2 VPWR a_81_21# X VPB sky130_fd_pr__pfet_01v8_hvt ad=0.26 pd=2.52 as=0.26 ps=2.52 w=1 l=0.15
X3 VPWR A1 a_299_297# VPB sky130_fd_pr__pfet_01v8_hvt ad=0.14 pd=1.28 as=0.1375 ps=1.275 w=1 l=0.15
X4 VGND a_81_21# X VNB sky130_fd_pr__nfet_01v8 ad=0.25675 pd=1.44 as=0.169 ps=1.82 w=0.65 l=0.15
X5 VGND A2 a_384_47# VNB sky130_fd_pr__nfet_01v8 ad=0.17225 pd=1.83 as=0.091 ps=0.93 w=0.65 l=0.15
X6 a_299_297# A2 VPWR VPB sky130_fd_pr__pfet_01v8_hvt ad=0.265 pd=2.53 as=0.14 ps=1.28 w=1 l=0.15
X7 a_384_47# A1 a_81_21# VNB sky130_fd_pr__nfet_01v8 ad=0.091 pd=0.93 as=0.08937 ps=0.925 w=0.65 l=0.15
.ends

.subckt sky130_fd_sc_hd__xnor2_1 VGND VPWR B Y A VPB VNB
X0 a_377_297# A VPWR VPB sky130_fd_pr__pfet_01v8_hvt ad=0.105 pd=1.21 as=0.365 ps=1.73 w=1 l=0.15
X1 a_47_47# B VPWR VPB sky130_fd_pr__pfet_01v8_hvt ad=0.135 pd=1.27 as=0.3 ps=2.6 w=1 l=0.15
X2 a_129_47# B a_47_47# VNB sky130_fd_pr__nfet_01v8 ad=0.06825 pd=0.86 as=0.169 ps=1.82 w=0.65 l=0.15
X3 a_285_47# B VGND VNB sky130_fd_pr__nfet_01v8 ad=0.08775 pd=0.92 as=0.169 ps=1.82 w=0.65 l=0.15
X4 Y a_47_47# a_285_47# VNB sky130_fd_pr__nfet_01v8 ad=0.195 pd=1.9 as=0.08775 ps=0.92 w=0.65 l=0.15
X5 VGND A a_129_47# VNB sky130_fd_pr__nfet_01v8 ad=0.08775 pd=0.92 as=0.06825 ps=0.86 w=0.65 l=0.15
X6 VPWR A a_47_47# VPB sky130_fd_pr__pfet_01v8_hvt ad=0.365 pd=1.73 as=0.135 ps=1.27 w=1 l=0.15
X7 VPWR a_47_47# Y VPB sky130_fd_pr__pfet_01v8_hvt ad=0.36 pd=2.72 as=0.165 ps=1.33 w=1 l=0.15
X8 Y B a_377_297# VPB sky130_fd_pr__pfet_01v8_hvt ad=0.165 pd=1.33 as=0.105 ps=1.21 w=1 l=0.15
X9 a_285_47# A VGND VNB sky130_fd_pr__nfet_01v8 ad=0.169 pd=1.82 as=0.08775 ps=0.92 w=0.65 l=0.15
.ends

.subckt sky130_fd_sc_hd__a21boi_0 VNB VPB VPWR VGND A1 A2 B1_N Y
X0 a_300_369# A2 VPWR VPB sky130_fd_pr__pfet_01v8_hvt ad=0.1696 pd=1.81 as=0.0896 ps=0.92 w=0.64 l=0.15
X1 a_400_47# A1 Y VNB sky130_fd_pr__nfet_01v8 ad=0.0441 pd=0.63 as=0.1113 ps=0.95 w=0.42 l=0.15
X2 VGND A2 a_400_47# VNB sky130_fd_pr__nfet_01v8 ad=0.1113 pd=1.37 as=0.0441 ps=0.63 w=0.42 l=0.15
X3 VGND B1_N a_27_47# VNB sky130_fd_pr__nfet_01v8 ad=0.1302 pd=1.04 as=0.1113 ps=1.37 w=0.42 l=0.15
X4 VPWR B1_N a_27_47# VPB sky130_fd_pr__pfet_01v8_hvt ad=0.1113 pd=1.37 as=0.1113 ps=1.37 w=0.42 l=0.15
X5 Y a_27_47# VGND VNB sky130_fd_pr__nfet_01v8 ad=0.1113 pd=0.95 as=0.1302 ps=1.04 w=0.42 l=0.15
X6 a_300_369# a_27_47# Y VPB sky130_fd_pr__pfet_01v8_hvt ad=0.0896 pd=0.92 as=0.1696 ps=1.81 w=0.64 l=0.15
X7 VPWR A1 a_300_369# VPB sky130_fd_pr__pfet_01v8_hvt ad=0.0896 pd=0.92 as=0.0896 ps=0.92 w=0.64 l=0.15
.ends

.subckt sky130_fd_sc_hd__o22a_1 VPB VNB VGND VPWR B2 A2 A1 B1 X
X0 a_78_199# B1 a_215_47# VNB sky130_fd_pr__nfet_01v8 ad=0.08775 pd=0.92 as=0.169 ps=1.82 w=0.65 l=0.15
X1 VPWR A1 a_493_297# VPB sky130_fd_pr__pfet_01v8_hvt ad=0.26 pd=2.52 as=0.105 ps=1.21 w=1 l=0.15
X2 a_493_297# A2 a_78_199# VPB sky130_fd_pr__pfet_01v8_hvt ad=0.105 pd=1.21 as=0.235 ps=1.47 w=1 l=0.15
X3 VPWR a_78_199# X VPB sky130_fd_pr__pfet_01v8_hvt ad=0.3725 pd=1.745 as=0.28 ps=2.56 w=1 l=0.15
X4 VGND A2 a_215_47# VNB sky130_fd_pr__nfet_01v8 ad=0.08775 pd=0.92 as=0.11375 ps=1 w=0.65 l=0.15
X5 a_78_199# B2 a_292_297# VPB sky130_fd_pr__pfet_01v8_hvt ad=0.235 pd=1.47 as=0.1175 ps=1.235 w=1 l=0.15
X6 a_215_47# A1 VGND VNB sky130_fd_pr__nfet_01v8 ad=0.169 pd=1.82 as=0.08775 ps=0.92 w=0.65 l=0.15
X7 a_215_47# B2 a_78_199# VNB sky130_fd_pr__nfet_01v8 ad=0.11375 pd=1 as=0.08775 ps=0.92 w=0.65 l=0.15
X8 a_292_297# B1 VPWR VPB sky130_fd_pr__pfet_01v8_hvt ad=0.1175 pd=1.235 as=0.3725 ps=1.745 w=1 l=0.15
X9 VGND a_78_199# X VNB sky130_fd_pr__nfet_01v8 ad=0.169 pd=1.82 as=0.169 ps=1.82 w=0.65 l=0.15
.ends

.subckt sky130_fd_sc_hd__a221o_1 VPWR VGND VPB VNB A1 A2 X B1 B2 C1
X0 a_465_47# A1 a_27_47# VNB sky130_fd_pr__nfet_01v8 ad=0.10725 pd=0.98 as=0.169 ps=1.82 w=0.65 l=0.15
X1 X a_27_47# VPWR VPB sky130_fd_pr__pfet_01v8_hvt ad=0.26 pd=2.52 as=0.1575 ps=1.315 w=1 l=0.15
X2 a_109_297# B1 a_193_297# VPB sky130_fd_pr__pfet_01v8_hvt ad=0.26 pd=2.52 as=0.135 ps=1.27 w=1 l=0.15
X3 a_193_297# B2 a_109_297# VPB sky130_fd_pr__pfet_01v8_hvt ad=0.135 pd=1.27 as=0.135 ps=1.27 w=1 l=0.15
X4 X a_27_47# VGND VNB sky130_fd_pr__nfet_01v8 ad=0.169 pd=1.82 as=0.10238 ps=0.965 w=0.65 l=0.15
X5 a_205_47# B2 VGND VNB sky130_fd_pr__nfet_01v8 ad=0.06825 pd=0.86 as=0.10725 ps=0.98 w=0.65 l=0.15
X6 VPWR A2 a_193_297# VPB sky130_fd_pr__pfet_01v8_hvt ad=0.1575 pd=1.315 as=0.165 ps=1.33 w=1 l=0.15
X7 a_193_297# A1 VPWR VPB sky130_fd_pr__pfet_01v8_hvt ad=0.165 pd=1.33 as=0.26 ps=2.52 w=1 l=0.15
X8 a_27_47# B1 a_205_47# VNB sky130_fd_pr__nfet_01v8 ad=0.169 pd=1.82 as=0.06825 ps=0.86 w=0.65 l=0.15
X9 a_109_297# C1 a_27_47# VPB sky130_fd_pr__pfet_01v8_hvt ad=0.135 pd=1.27 as=0.26 ps=2.52 w=1 l=0.15
X10 VGND C1 a_27_47# VNB sky130_fd_pr__nfet_01v8 ad=0.10725 pd=0.98 as=0.169 ps=1.82 w=0.65 l=0.15
X11 VGND A2 a_465_47# VNB sky130_fd_pr__nfet_01v8 ad=0.10238 pd=0.965 as=0.10725 ps=0.98 w=0.65 l=0.15
.ends

.subckt tt_um_ares_sentinel_project VGND VPWR clk ena rst_n ui_in[0] ui_in[1] ui_in[2]
+ ui_in[3] ui_in[4] ui_in[5] ui_in[6] ui_in[7] uio_in[0] uio_in[1] uio_in[2] uio_in[3]
+ uio_in[4] uio_in[5] uio_in[6] uio_in[7] uio_oe[0] uio_oe[1] uio_oe[2] uio_oe[3]
+ uio_oe[4] uio_oe[5] uio_oe[6] uio_oe[7] uio_out[0] uio_out[1] uio_out[2] uio_out[3]
+ uio_out[4] uio_out[5] uio_out[6] uio_out[7] uo_out[0] uo_out[1] uo_out[2] uo_out[3]
+ uo_out[4] uo_out[5] uo_out[6] uo_out[7]
X_1270_ VGND VPWR VPWR VGND _1270_/CLK _1270_/D _1270_/RESET_B _1270_/Q sky130_fd_sc_hd__dfrtp_1
X_0985_ VPWR VGND VGND VPWR _0985_/A _0985_/Y _0985_/B sky130_fd_sc_hd__nand2_1
X_0770_ VGND VPWR VPWR VGND _0770_/A3 _0770_/A2 _0770_/A1 _0770_/Y _0770_/B1 sky130_fd_sc_hd__a31oi_1
X_1253_ VGND VPWR VPWR VGND _1253_/CLK _1253_/D _1253_/RESET_B _1253_/Q sky130_fd_sc_hd__dfrtp_1
X_1184_ _1184_/Q _1184_/CLK _1184_/D VPWR VGND VPWR VGND sky130_fd_sc_hd__dfxtp_1
Xclkbuf_4_12_0_clk VGND VPWR clkbuf_4_12_0_clk/A clkbuf_4_12_0_clk/X VPWR VGND sky130_fd_sc_hd__clkbuf_2
X_0968_ VPWR VGND VGND VPWR _0968_/A _0968_/Y _0968_/B sky130_fd_sc_hd__nand2_1
X_0899_ VPWR VGND VGND VPWR _0899_/A _0899_/Y _0899_/B sky130_fd_sc_hd__nand2_1
X_0822_ VPWR VGND VPWR VGND _0822_/A _0822_/C _0822_/D _0822_/Y _0822_/B sky130_fd_sc_hd__nand4_1
X_0684_ VPWR VGND VGND VPWR _0684_/A _0684_/B _0684_/Y sky130_fd_sc_hd__nor2_1
X_0753_ VGND VPWR _0753_/X _0753_/B _0753_/A _0753_/C VPWR VGND sky130_fd_sc_hd__and3_1
X_1305_ VGND VPWR VPWR VGND _1305_/CLK _1305_/D _1305_/RESET_B _1305_/Q sky130_fd_sc_hd__dfrtp_1
X_1236_ VGND VPWR VPWR VGND _1236_/CLK _1236_/D _1236_/RESET_B _1236_/Q sky130_fd_sc_hd__dfrtp_1
X_1167_ VPWR VGND VPWR VGND _1167_/B1 _1167_/A1 _1167_/A2 _1167_/X _1167_/B2 sky130_fd_sc_hd__a22o_1
X_1098_ VPWR VGND VGND VPWR _1098_/A _1098_/Y _1098_/B sky130_fd_sc_hd__nand2_1
X_1021_ VPWR VGND VGND VPWR _1021_/A _1021_/Y _1021_/B sky130_fd_sc_hd__nand2_1
X_0805_ VPWR VGND VGND VPWR _0805_/A _0805_/B _0805_/Y sky130_fd_sc_hd__nor2_1
X_0598_ VGND VPWR VPWR VGND _0598_/B2 _0598_/Y _0598_/B1 _0598_/A1 _0598_/A2 _0598_/A3
+ sky130_fd_sc_hd__a32oi_1
X_0667_ VPWR VGND VGND VPWR _0667_/A _0667_/Y _0667_/B sky130_fd_sc_hd__nand2_1
X_0736_ VGND VPWR VPWR VGND _0736_/C2 _0736_/C1 _0736_/B1 _0736_/A2 _0736_/A1 _0736_/Y
+ _0736_/B2 sky130_fd_sc_hd__a222oi_1
X_1219_ VGND VPWR VPWR VGND _1219_/CLK _1219_/D _1219_/RESET_B _1219_/Q sky130_fd_sc_hd__dfrtp_1
X_1004_ VPWR VGND VGND VPWR _1004_/A _1004_/Y _1004_/B sky130_fd_sc_hd__nand2_1
X_0719_ VGND VPWR VPWR VGND _0719_/C2 _0719_/C1 _0719_/B1 _0719_/A2 _0719_/A1 _0719_/Y
+ _0719_/B2 sky130_fd_sc_hd__a222oi_1
X_0984_ VGND VPWR VGND VPWR _0984_/B1 _0984_/A1 _0984_/Y _0984_/A2 sky130_fd_sc_hd__o21ai_0
X_1252_ VGND VPWR VPWR VGND _1252_/CLK _1252_/D _1252_/RESET_B _1252_/Q sky130_fd_sc_hd__dfrtp_1
X_1183_ _1183_/Q _1183_/CLK _1183_/D VPWR VGND VPWR VGND sky130_fd_sc_hd__dfxtp_1
X_0967_ VPWR VGND VGND VPWR _0967_/A _0967_/Y _0967_/B sky130_fd_sc_hd__nand2_1
X_0898_ VPWR VGND VGND VPWR _0898_/A _0898_/Y _0898_/B sky130_fd_sc_hd__nand2_1
X_0752_ VGND VPWR VPWR VGND _0752_/A3 _0752_/A2 _0752_/A1 _0752_/Y _0752_/B1 sky130_fd_sc_hd__a31oi_1
X_0821_ VPWR VGND VGND VPWR _0821_/D_N _0821_/C _0821_/Y _0821_/B _0821_/A sky130_fd_sc_hd__nor4b_1
X_0683_ VPWR VGND VGND VPWR _0683_/A _0683_/Y _0683_/B sky130_fd_sc_hd__nand2_1
X_1304_ VGND VPWR VPWR VGND _1304_/CLK _1304_/D _1304_/RESET_B _1304_/Q sky130_fd_sc_hd__dfrtp_1
X_1166_ VPWR VGND VGND VPWR _1166_/A _1166_/Y _1166_/B sky130_fd_sc_hd__nand2_1
X_1235_ VGND VPWR VPWR VGND _1235_/CLK _1235_/D _1235_/RESET_B _1235_/Q sky130_fd_sc_hd__dfrtp_1
X_1097_ VPWR VGND VGND VPWR _1097_/A _1097_/Y _1097_/B sky130_fd_sc_hd__nand2_1
Xclkbuf_4_11_0_clk VGND VPWR clkbuf_4_11_0_clk/A clkbuf_4_11_0_clk/X VPWR VGND sky130_fd_sc_hd__clkbuf_2
X_1020_ VPWR VGND VGND VPWR _1020_/A _1020_/Y _1020_/B sky130_fd_sc_hd__nand2_1
X_0804_ VPWR VGND VGND VPWR _0804_/C_N _0804_/B _0804_/Y _0804_/A sky130_fd_sc_hd__nor3b_1
X_0735_ VGND VPWR VPWR VGND _0735_/C2 _0735_/C1 _0735_/B1 _0735_/A2 _0735_/A1 _0735_/Y
+ _0735_/B2 sky130_fd_sc_hd__a222oi_1
X_0597_ VPWR VGND VPWR VGND _0597_/A _0597_/C _0597_/D _0597_/Y _0597_/B sky130_fd_sc_hd__nand4_1
X_0666_ VPWR VGND VGND VPWR _0666_/A _0666_/B _0666_/Y _0666_/C sky130_fd_sc_hd__nand3_1
X_1218_ VGND VPWR VPWR VGND _1218_/CLK _1218_/D _1218_/RESET_B _1218_/Q sky130_fd_sc_hd__dfrtp_1
X_1149_ VGND VPWR VPWR VGND _1149_/X _1149_/B _1149_/A sky130_fd_sc_hd__and2_0
X_1003_ VPWR VGND VGND VPWR _1003_/A _1003_/Y _1003_/B sky130_fd_sc_hd__nand2_1
X_0718_ VPWR VGND VGND VPWR _0718_/A _0718_/Y _0718_/B sky130_fd_sc_hd__nand2_1
X_0649_ VPWR VGND VGND VPWR _0649_/A _0649_/Y _0649_/B sky130_fd_sc_hd__nand2_1
X_0983_ VPWR VGND VGND VPWR _0983_/A _0983_/Y _0983_/B sky130_fd_sc_hd__nand2_1
X_1182_ _1182_/Q _1182_/CLK _1182_/D VPWR VGND VPWR VGND sky130_fd_sc_hd__dfxtp_1
X_1251_ VGND VPWR VPWR VGND _1251_/CLK _1251_/D _1251_/RESET_B _1251_/Q sky130_fd_sc_hd__dfrtp_1
X_0897_ VGND VPWR VGND VPWR _0897_/B1 _0897_/A1 _0897_/Y _0897_/A2 sky130_fd_sc_hd__o21ai_0
X_0966_ VGND VPWR VGND VPWR _0966_/B1 _0966_/A1 _0966_/Y _0966_/A2 sky130_fd_sc_hd__o21ai_0
X_0820_ VPWR VGND VPWR VGND _0820_/A _0820_/C _0820_/D _0820_/Y _0820_/B sky130_fd_sc_hd__nand4_1
X_0751_ VGND VPWR _0751_/X _0751_/B _0751_/A _0751_/C VPWR VGND sky130_fd_sc_hd__and3_1
X_1303_ VGND VPWR VPWR VGND _1303_/CLK _1303_/D _1303_/RESET_B _1303_/Q sky130_fd_sc_hd__dfrtp_1
X_0682_ VPWR VGND VGND VPWR _0682_/A _0682_/B _0682_/Y sky130_fd_sc_hd__nor2_1
X_1165_ VPWR VGND VGND VPWR _1165_/D_N _1165_/C _1165_/Y _1165_/B _1165_/A sky130_fd_sc_hd__nor4b_1
X_1096_ VPWR VGND VGND VPWR _1096_/A _1096_/Y _1096_/B sky130_fd_sc_hd__nand2_1
X_1234_ VGND VPWR VPWR VGND _1234_/CLK _1234_/D _1234_/RESET_B _1234_/Q sky130_fd_sc_hd__dfrtp_1
X_0949_ VPWR VGND VGND VPWR _0949_/A _0949_/Y _0949_/B sky130_fd_sc_hd__nand2_1
X_0665_ VGND VPWR VGND VPWR _0665_/B1 _0665_/A1 _0665_/Y _0665_/A2 sky130_fd_sc_hd__o21ai_0
X_0803_ VPWR VGND VGND VPWR _0803_/A _0803_/Y _0803_/B sky130_fd_sc_hd__nand2_1
X_0734_ VPWR VGND VPWR VGND _0734_/B2 _0734_/B1 _0734_/Y _0734_/A1 _0734_/A2 sky130_fd_sc_hd__a22oi_1
X_0596_ VPWR VGND VGND VPWR _0596_/A _0596_/B _0596_/Y sky130_fd_sc_hd__nor2_1
X_1148_ VPWR VGND VGND VPWR _1148_/C _1148_/B _1148_/A _1148_/Y sky130_fd_sc_hd__nor3_1
X_1217_ VGND VPWR VPWR VGND _1217_/CLK _1217_/D _1217_/RESET_B _1217_/Q sky130_fd_sc_hd__dfrtp_1
X_1079_ VPWR VGND VGND VPWR _1079_/A _1079_/Y _1079_/B sky130_fd_sc_hd__nand2_1
X_1002_ VGND VPWR VGND VPWR _1002_/B1 _1002_/A1 _1002_/Y _1002_/A2 sky130_fd_sc_hd__o21ai_0
X_0648_ VPWR VGND VGND VPWR _0648_/A _0648_/B _0648_/Y sky130_fd_sc_hd__nor2_1
X_0717_ VGND VPWR VPWR VGND _0717_/A3 _0717_/A2 _0717_/A1 _0717_/Y _0717_/B1 sky130_fd_sc_hd__a31oi_1
X_0579_ VPWR VGND VGND VPWR _0579_/A _0579_/Y sky130_fd_sc_hd__clkinv_1
Xclkbuf_4_10_0_clk VGND VPWR clkbuf_4_10_0_clk/A clkbuf_4_10_0_clk/X VPWR VGND sky130_fd_sc_hd__clkbuf_2
X_0982_ VPWR VGND VGND VPWR _0982_/A _0982_/Y _0982_/B sky130_fd_sc_hd__nand2_1
X_1250_ VGND VPWR VPWR VGND _1250_/CLK _1250_/D _1250_/RESET_B _1250_/Q sky130_fd_sc_hd__dfrtp_1
X_1181_ VGND VPWR VPWR VGND _1181_/CLK _1181_/D _1181_/RESET_B _1181_/Q sky130_fd_sc_hd__dfrtp_1
X_0965_ VPWR VGND VGND VPWR _0965_/A _0965_/Y _0965_/B sky130_fd_sc_hd__nand2_1
X_0896_ VPWR VGND VGND VPWR _0896_/A _0896_/Y _0896_/B sky130_fd_sc_hd__nand2_1
X_0681_ VPWR VGND VGND VPWR _0681_/A_N _0681_/B _0681_/Y sky130_fd_sc_hd__nand2b_1
X_0750_ VGND VPWR VPWR VGND _0750_/C2 _0750_/C1 _0750_/B1 _0750_/A2 _0750_/A1 _0750_/Y
+ _0750_/B2 sky130_fd_sc_hd__a222oi_1
X_1302_ VGND VPWR VPWR VGND _1302_/CLK _1302_/D _1302_/RESET_B _1302_/Q sky130_fd_sc_hd__dfrtp_1
X_1233_ VGND VPWR VPWR VGND _1233_/CLK _1233_/D _1233_/RESET_B _1233_/Q sky130_fd_sc_hd__dfrtp_1
X_1164_ VGND VPWR VPWR VGND _1164_/X _1164_/A3 _1164_/A2 _1164_/A1 _1164_/B1 _1164_/B2
+ sky130_fd_sc_hd__a32o_1
X_1095_ VGND VPWR VGND VPWR _1095_/B1 _1095_/A1 _1095_/Y _1095_/A2 sky130_fd_sc_hd__o21ai_0
X_0948_ VPWR VGND VGND VPWR _0948_/A _0948_/Y _0948_/B sky130_fd_sc_hd__nand2_1
X_0879_ VGND VPWR VGND VPWR _0879_/B1 _0879_/A1 _0879_/Y _0879_/A2 sky130_fd_sc_hd__o21ai_0
X_0802_ VPWR VGND VGND VPWR _0802_/A _0802_/Y _0802_/B sky130_fd_sc_hd__nand2_1
X_0664_ VGND VPWR VPWR VGND _0664_/B2 _0664_/Y _0664_/B1 _0664_/A1 _0664_/A2 _0664_/A3
+ sky130_fd_sc_hd__a32oi_1
X_0733_ VGND VPWR VPWR VGND _0733_/C2 _0733_/C1 _0733_/B1 _0733_/A2 _0733_/A1 _0733_/Y
+ _0733_/B2 sky130_fd_sc_hd__a222oi_1
X_0595_ VPWR VGND VGND VPWR _0595_/X _0595_/SLEEP _0595_/A sky130_fd_sc_hd__lpflow_inputiso1p_1
X_1216_ VGND VPWR VPWR VGND _1216_/CLK _1216_/D _1216_/RESET_B _1216_/Q sky130_fd_sc_hd__dfrtp_1
X_1147_ VGND VPWR VPWR VGND _1147_/D1 _1147_/C1 _1147_/A2 _1147_/A1 _1147_/B1 _1147_/Y
+ sky130_fd_sc_hd__a2111oi_0
X_1078_ VPWR VGND VGND VPWR _1078_/A _1078_/Y _1078_/B sky130_fd_sc_hd__nand2_1
X_1001_ VPWR VGND VGND VPWR _1001_/A _1001_/Y _1001_/B sky130_fd_sc_hd__nand2_1
X_0647_ VPWR VGND VGND VPWR _0647_/A _0647_/Y _0647_/B sky130_fd_sc_hd__nand2_1
X_0716_ VGND VPWR VPWR VGND _0716_/Y _0716_/B1 _0716_/C1 _0716_/A1 _0716_/A2 _0716_/B2
+ sky130_fd_sc_hd__a221oi_1
X_0981_ VPWR VGND VGND VPWR _0981_/A _0981_/Y _0981_/B sky130_fd_sc_hd__nand2_1
X_1180_ VGND VPWR VPWR VGND _1180_/CLK _1180_/D _1180_/RESET_B _1180_/Q sky130_fd_sc_hd__dfrtp_1
X_0964_ VPWR VGND VGND VPWR _0964_/A _0964_/Y _0964_/B sky130_fd_sc_hd__nand2_1
X_0895_ VPWR VGND VGND VPWR _0895_/A _0895_/Y _0895_/B sky130_fd_sc_hd__nand2_1
X_0680_ VPWR VGND VGND VPWR _0680_/A_N _0680_/B _0680_/Y sky130_fd_sc_hd__nand2b_1
X_1301_ VGND VPWR VPWR VGND _1301_/CLK _1301_/D _1301_/RESET_B _1301_/Q sky130_fd_sc_hd__dfrtp_1
X_1232_ VGND VPWR VPWR VGND _1232_/CLK _1232_/D _1232_/RESET_B _1232_/Q sky130_fd_sc_hd__dfrtp_1
X_1163_ VPWR VGND VGND VPWR _1163_/A _1163_/Y _1163_/B sky130_fd_sc_hd__nand2_1
X_1094_ VPWR VGND VGND VPWR _1094_/A _1094_/Y _1094_/B sky130_fd_sc_hd__nand2_1
X_0947_ VPWR VGND VGND VPWR _0947_/A _0947_/Y _0947_/B sky130_fd_sc_hd__nand2_1
X_0878_ VPWR VGND VGND VPWR _0878_/A _0878_/Y _0878_/B sky130_fd_sc_hd__nand2_1
X_0801_ VPWR VGND VGND VPWR _0801_/A _0801_/Y _0801_/B sky130_fd_sc_hd__nand2_1
X_0663_ VGND VPWR VPWR VGND _0663_/X _0663_/B _0663_/A sky130_fd_sc_hd__and2_0
X_0594_ VPWR VGND VGND VPWR _0594_/A _0594_/B _0594_/Y _0594_/C sky130_fd_sc_hd__nand3_1
X_0732_ VPWR VGND VGND VPWR _0732_/A _0732_/Y _0732_/B sky130_fd_sc_hd__nand2_1
X_1146_ VGND VPWR VPWR VGND _1146_/A3 _1146_/A2 _1146_/A1 _1146_/Y _1146_/B1 sky130_fd_sc_hd__a31oi_1
X_1215_ VGND VPWR VPWR VGND _1215_/CLK _1215_/D _1215_/RESET_B _1215_/Q sky130_fd_sc_hd__dfrtp_1
X_1077_ VGND VPWR VGND VPWR _1077_/B1 _1077_/A1 _1077_/Y _1077_/A2 sky130_fd_sc_hd__o21ai_0
X_1000_ VPWR VGND VGND VPWR _1000_/A _1000_/Y _1000_/B sky130_fd_sc_hd__nand2_1
X_0715_ VPWR VGND VGND VPWR _0715_/A _0715_/Y _0715_/B sky130_fd_sc_hd__nand2_1
X_0646_ VGND VPWR VPWR VGND _0646_/C2 _0646_/C1 _0646_/B1 _0646_/A2 _0646_/A1 _0646_/Y
+ _0646_/B2 sky130_fd_sc_hd__a222oi_1
X_1129_ VPWR VGND VGND VPWR _1129_/A _1129_/Y _1129_/B sky130_fd_sc_hd__nand2_1
X_0629_ VGND VPWR VGND VPWR _0629_/B1 _0629_/A1 _0629_/Y _0629_/A2 sky130_fd_sc_hd__o21ai_0
X_0980_ VPWR VGND VGND VPWR _0980_/A _0980_/Y _0980_/B sky130_fd_sc_hd__nand2_1
X_0963_ VGND VPWR VGND VPWR _0963_/B1 _0963_/A1 _0963_/Y _0963_/A2 sky130_fd_sc_hd__o21ai_0
X_0894_ VGND VPWR VGND VPWR _0894_/B1 _0894_/A1 _0894_/Y _0894_/A2 sky130_fd_sc_hd__o21ai_0
X_1300_ VPWR VGND VPWR VGND _1300_/Q _1300_/SET_B _1300_/D _1300_/CLK sky130_fd_sc_hd__dfstp_2
X_1162_ VPWR VGND VPWR VGND _1162_/A2 _1162_/A1 _1162_/B1 _1162_/Y sky130_fd_sc_hd__a21oi_1
X_1231_ VGND VPWR VPWR VGND _1231_/CLK _1231_/D _1231_/RESET_B _1231_/Q sky130_fd_sc_hd__dfrtp_1
X_1093_ VPWR VGND VGND VPWR _1093_/A _1093_/Y _1093_/B sky130_fd_sc_hd__nand2_1
X_0877_ VPWR VGND VGND VPWR _0877_/A _0877_/Y _0877_/B sky130_fd_sc_hd__nand2_1
X_0946_ VPWR VGND VGND VPWR _0946_/A _0946_/Y _0946_/B sky130_fd_sc_hd__nand2_1
X_0800_ VPWR VGND VGND VPWR _0800_/X _0800_/SLEEP _0800_/A sky130_fd_sc_hd__lpflow_inputiso1p_1
X_0731_ VGND VPWR VPWR VGND _0731_/A3 _0731_/A2 _0731_/A1 _0731_/Y _0731_/B1 sky130_fd_sc_hd__a31oi_1
X_0662_ VPWR VGND VGND VPWR _0662_/A _0662_/Y _0662_/B sky130_fd_sc_hd__nand2_1
X_0593_ VPWR VGND VGND VPWR _0593_/A _0593_/Y _0593_/B sky130_fd_sc_hd__nand2_1
X_1145_ VPWR VGND VGND VPWR _1145_/C _1145_/B _1145_/A _1145_/Y sky130_fd_sc_hd__nor3_1
X_1214_ VGND VPWR VPWR VGND _1214_/CLK _1214_/D _1214_/RESET_B _1214_/Q sky130_fd_sc_hd__dfrtp_1
X_1076_ VPWR VGND VGND VPWR _1076_/A _1076_/Y _1076_/B sky130_fd_sc_hd__nand2_1
X_0929_ VPWR VGND VGND VPWR _0929_/A _0929_/Y _0929_/B sky130_fd_sc_hd__nand2_1
X_0645_ VPWR VGND VGND VPWR _0645_/A _0645_/Y _0645_/B sky130_fd_sc_hd__nand2_1
X_0714_ VGND VPWR VPWR VGND _0714_/C2 _0714_/C1 _0714_/B1 _0714_/A2 _0714_/A1 _0714_/Y
+ _0714_/B2 sky130_fd_sc_hd__a222oi_1
X_1128_ VPWR VGND VGND VPWR _1128_/A _1128_/Y _1128_/B sky130_fd_sc_hd__nand2_1
X_1059_ VGND VPWR VGND VPWR _1059_/B1 _1059_/A1 _1059_/Y _1059_/A2 sky130_fd_sc_hd__o21ai_0
XPHY_0 VPWR VGND VPWR VGND sky130_fd_sc_hd__decap_3
X_0628_ VPWR VGND VGND VPWR _0628_/A _0628_/B _0628_/Y sky130_fd_sc_hd__nor2_1
X_0962_ VPWR VGND VGND VPWR _0962_/A _0962_/Y _0962_/B sky130_fd_sc_hd__nand2_1
X_0893_ VPWR VGND VGND VPWR _0893_/A _0893_/Y _0893_/B sky130_fd_sc_hd__nand2_1
X_1092_ VPWR VGND VGND VPWR _1092_/A _1092_/Y _1092_/B sky130_fd_sc_hd__nand2_1
X_1161_ VPWR VGND VPWR VGND _1161_/B _1161_/C _1161_/A _1161_/X sky130_fd_sc_hd__or3_1
X_1230_ VGND VPWR VPWR VGND _1230_/CLK _1230_/D _1230_/RESET_B _1230_/Q sky130_fd_sc_hd__dfrtp_1
X_0945_ VPWR VGND VGND VPWR _0945_/A _0945_/Y _0945_/B sky130_fd_sc_hd__nand2_1
X_0876_ VGND VPWR VGND VPWR _0876_/B1 _0876_/A1 _0876_/Y _0876_/A2 sky130_fd_sc_hd__o21ai_0
X_0661_ VPWR VGND VGND VPWR _0661_/C _0661_/B _0661_/A _0661_/Y sky130_fd_sc_hd__nor3_1
X_0730_ VGND VPWR _0730_/X _0730_/B _0730_/A _0730_/C VPWR VGND sky130_fd_sc_hd__and3_1
X_0592_ VGND VPWR VGND VPWR _0592_/X _0592_/A2 _0592_/B1 _0592_/A1 _0592_/C1 sky130_fd_sc_hd__a211o_1
X_1213_ VGND VPWR VPWR VGND _1213_/CLK _1213_/D _1213_/RESET_B _1213_/Q sky130_fd_sc_hd__dfrtp_1
X_1144_ VPWR VGND VPWR VGND _1144_/A2 _1144_/A1 _1144_/B1 _1144_/Y sky130_fd_sc_hd__a21oi_1
X_1075_ VPWR VGND VGND VPWR _1075_/A _1075_/Y _1075_/B sky130_fd_sc_hd__nand2_1
X_0859_ VPWR VGND VGND VPWR _0859_/A _0859_/Y _0859_/B sky130_fd_sc_hd__nand2_1
X_0928_ VPWR VGND VGND VPWR _0928_/A _0928_/Y _0928_/B sky130_fd_sc_hd__nand2_1
X_0644_ VPWR VGND VPWR VGND _0644_/A _0644_/C _0644_/D _0644_/Y _0644_/B sky130_fd_sc_hd__nand4_1
X_0713_ VGND VPWR VPWR VGND _0713_/C2 _0713_/C1 _0713_/B1 _0713_/A2 _0713_/A1 _0713_/Y
+ _0713_/B2 sky130_fd_sc_hd__a222oi_1
X_1127_ VPWR VGND VGND VPWR _1127_/A _1127_/Y _1127_/B sky130_fd_sc_hd__nand2_1
X_1058_ VPWR VGND VGND VPWR _1058_/A _1058_/Y _1058_/B sky130_fd_sc_hd__nand2_1
XPHY_1 VPWR VGND VPWR VGND sky130_fd_sc_hd__decap_3
X_0627_ VPWR VGND VGND VPWR _0627_/A _0627_/Y _0627_/B sky130_fd_sc_hd__nand2_1
X_0961_ VPWR VGND VGND VPWR _0961_/A _0961_/Y _0961_/B sky130_fd_sc_hd__nand2_1
X_0892_ VPWR VGND VGND VPWR _0892_/A _0892_/Y _0892_/B sky130_fd_sc_hd__nand2_1
X_1091_ VPWR VGND VGND VPWR _1091_/A _1091_/Y _1091_/B sky130_fd_sc_hd__nand2_1
X_1160_ VGND VPWR VGND VPWR _1160_/B1 _1160_/A1 _1160_/Y _1160_/A2 sky130_fd_sc_hd__o21ai_0
X_0944_ VPWR VGND VGND VPWR _0944_/A _0944_/Y _0944_/B sky130_fd_sc_hd__nand2_1
X_0875_ VPWR VGND VGND VPWR _0875_/A _0875_/Y _0875_/B sky130_fd_sc_hd__nand2_1
X_1289_ VGND VPWR VPWR VGND _1289_/CLK _1289_/D _1289_/RESET_B _1289_/Q sky130_fd_sc_hd__dfrtp_1
X_0660_ VPWR VGND VGND VPWR _0660_/C _0660_/B _0660_/A _0660_/Y sky130_fd_sc_hd__nor3_1
X_0591_ VGND VPWR VGND VPWR _0591_/X _0591_/A2 _0591_/B1 _0591_/A1 _0591_/C1 sky130_fd_sc_hd__a211o_1
X_1212_ VGND VPWR VPWR VGND _1212_/CLK _1212_/D _1212_/RESET_B _1212_/Q sky130_fd_sc_hd__dfrtp_1
X_1143_ VGND VPWR _1143_/X _1143_/B _1143_/A _1143_/C VPWR VGND sky130_fd_sc_hd__and3_1
X_1074_ VPWR VGND VGND VPWR _1074_/A _1074_/Y _1074_/B sky130_fd_sc_hd__nand2_1
X_0927_ VGND VPWR VGND VPWR _0927_/B1 _0927_/A1 _0927_/Y _0927_/A2 sky130_fd_sc_hd__o21ai_0
X_0789_ VPWR VGND VPWR VGND _0789_/A2 _0789_/A1 _0789_/B1 _0789_/Y sky130_fd_sc_hd__a21oi_1
X_0858_ VGND VPWR VGND VPWR _0858_/B1 _0858_/A1 _0858_/Y _0858_/A2 sky130_fd_sc_hd__o21ai_0
X_0643_ VPWR VGND VGND VPWR _0643_/A _0643_/B _0643_/Y _0643_/C sky130_fd_sc_hd__nand3_1
X_0712_ VGND VPWR VPWR VGND _0712_/C2 _0712_/C1 _0712_/B1 _0712_/A2 _0712_/A1 _0712_/Y
+ _0712_/B2 sky130_fd_sc_hd__a222oi_1
X_1126_ VPWR VGND VGND VPWR _1126_/A _1126_/Y _1126_/B sky130_fd_sc_hd__nand2_1
X_1057_ VPWR VGND VGND VPWR _1057_/A _1057_/Y _1057_/B sky130_fd_sc_hd__nand2_1
XPHY_2 VPWR VGND VPWR VGND sky130_fd_sc_hd__decap_3
Xclkbuf_0_clk VGND VPWR VGND VPWR clkbuf_0_clk/A clkbuf_0_clk/X sky130_fd_sc_hd__clkbuf_16
X_0626_ VPWR VGND VGND VPWR _0626_/A1 _0626_/A2 _0626_/B1 _0626_/Y _0626_/B2 _0626_/A3
+ sky130_fd_sc_hd__o32ai_1
X_1109_ VPWR VGND VGND VPWR _1109_/A _1109_/Y _1109_/B sky130_fd_sc_hd__nand2_1
X_0609_ VGND VPWR VGND VPWR _0609_/B1 _0609_/A1 _0609_/Y _0609_/A2 sky130_fd_sc_hd__o21ai_0
X_0960_ VPWR VGND VGND VPWR _0960_/A _0960_/Y _0960_/B sky130_fd_sc_hd__nand2_1
X_0891_ VGND VPWR VGND VPWR _0891_/B1 _0891_/A1 _0891_/Y _0891_/A2 sky130_fd_sc_hd__o21ai_0
X_1090_ VPWR VGND VGND VPWR _1090_/A _1090_/Y _1090_/B sky130_fd_sc_hd__nand2_1
X_0943_ VPWR VGND VGND VPWR _0943_/A _0943_/Y _0943_/B sky130_fd_sc_hd__nand2_1
X_0874_ VPWR VGND VGND VPWR _0874_/A _0874_/Y _0874_/B sky130_fd_sc_hd__nand2_1
X_1288_ VGND VPWR VPWR VGND _1288_/CLK _1288_/D _1288_/RESET_B _1288_/Q sky130_fd_sc_hd__dfrtp_1
X_0590_ VPWR VGND VGND VPWR _0590_/A1 _0590_/A2 _0590_/B1 _0590_/B2 _0590_/Y sky130_fd_sc_hd__o22ai_1
X_1142_ VPWR VGND VPWR VGND _1142_/A2 _1142_/A1 _1142_/B1 _1142_/Y sky130_fd_sc_hd__a21oi_1
X_1211_ VGND VPWR VPWR VGND _1211_/CLK _1211_/D _1211_/RESET_B _1211_/Q sky130_fd_sc_hd__dfrtp_1
X_1073_ VPWR VGND VGND VPWR _1073_/A _1073_/Y _1073_/B sky130_fd_sc_hd__nand2_1
X_0926_ VPWR VGND VGND VPWR _0926_/A _0926_/Y _0926_/B sky130_fd_sc_hd__nand2_1
X_0857_ VPWR VGND VGND VPWR _0857_/A _0857_/Y _0857_/B sky130_fd_sc_hd__nand2_1
X_0788_ VPWR VGND VGND VPWR _0788_/A _0788_/Y _0788_/B sky130_fd_sc_hd__nand2_1
X_0711_ VPWR VGND VGND VPWR _0711_/A _0711_/Y _0711_/B sky130_fd_sc_hd__nand2_1
X_0642_ VPWR VGND VPWR VGND _0642_/A2 _0642_/A1 _0642_/B1 _0642_/Y sky130_fd_sc_hd__a21oi_1
X_1125_ VGND VPWR VGND VPWR _1125_/B1 _1125_/A1 _1125_/Y _1125_/A2 sky130_fd_sc_hd__o21ai_0
X_1056_ VPWR VGND VGND VPWR _1056_/A _1056_/Y _1056_/B sky130_fd_sc_hd__nand2_1
X_0909_ VGND VPWR VGND VPWR _0909_/B1 _0909_/A1 _0909_/Y _0909_/A2 sky130_fd_sc_hd__o21ai_0
XPHY_3 VPWR VGND VPWR VGND sky130_fd_sc_hd__decap_3
X_0625_ VPWR VGND _0625_/A1 _0625_/A2 _0625_/A3 _0625_/Y _0625_/B1 VPWR VGND sky130_fd_sc_hd__o31ai_1
X_1039_ VPWR VGND VGND VPWR _1039_/A _1039_/Y _1039_/B sky130_fd_sc_hd__nand2_1
X_1108_ VPWR VGND VGND VPWR _1108_/A _1108_/Y _1108_/B sky130_fd_sc_hd__nand2_1
X_0608_ VGND VPWR VPWR VGND _0608_/A3 _0608_/A2 _0608_/A1 _0608_/Y _0608_/B1 sky130_fd_sc_hd__a31oi_1
X_0890_ VPWR VGND VGND VPWR _0890_/A _0890_/Y _0890_/B sky130_fd_sc_hd__nand2_1
X_0873_ VGND VPWR VGND VPWR _0873_/B1 _0873_/A1 _0873_/Y _0873_/A2 sky130_fd_sc_hd__o21ai_0
X_0942_ VGND VPWR VGND VPWR _0942_/B1 _0942_/A1 _0942_/Y _0942_/A2 sky130_fd_sc_hd__o21ai_0
X_1287_ VGND VPWR VPWR VGND _1287_/CLK _1287_/D _1287_/RESET_B _1287_/Q sky130_fd_sc_hd__dfrtp_1
X_1141_ VPWR VGND VPWR VGND _1141_/B2 _1141_/B1 _1141_/Y _1141_/A1 _1141_/A2 sky130_fd_sc_hd__a22oi_1
X_1210_ VGND VPWR VPWR VGND _1210_/CLK _1210_/D _1210_/RESET_B _1210_/Q sky130_fd_sc_hd__dfrtp_1
X_1072_ VPWR VGND VGND VPWR _1072_/A _1072_/Y _1072_/B sky130_fd_sc_hd__nand2_1
X_0787_ VGND VPWR VGND VPWR _0787_/B1 _0787_/A1 _0787_/Y _0787_/A2 sky130_fd_sc_hd__o21ai_0
X_0925_ VPWR VGND VGND VPWR _0925_/A _0925_/Y _0925_/B sky130_fd_sc_hd__nand2_1
X_0856_ VPWR VGND VGND VPWR _0856_/A _0856_/Y _0856_/B sky130_fd_sc_hd__nand2_1
X_0710_ VPWR VGND VGND VPWR _0710_/A _0710_/B _0710_/Y sky130_fd_sc_hd__nor2_1
X_0641_ VPWR VGND VPWR VGND _0641_/B _0641_/D _0641_/C _0641_/A _0641_/X sky130_fd_sc_hd__or4_1
X_1124_ VPWR VGND VGND VPWR _1124_/A _1124_/Y _1124_/B sky130_fd_sc_hd__nand2_1
X_1055_ VPWR VGND VGND VPWR _1055_/A _1055_/Y _1055_/B sky130_fd_sc_hd__nand2_1
X_0908_ VPWR VGND VGND VPWR _0908_/A _0908_/Y _0908_/B sky130_fd_sc_hd__nand2_1
X_0839_ VPWR VGND VGND VPWR _0839_/Y _0839_/C _0839_/B _0839_/D _0839_/A_N sky130_fd_sc_hd__nand4b_1
XPHY_4 VPWR VGND VPWR VGND sky130_fd_sc_hd__decap_3
X_0624_ VPWR VGND VGND VPWR _0624_/A _0624_/Y _0624_/B sky130_fd_sc_hd__nand2_1
X_1038_ VPWR VGND VGND VPWR _1038_/A _1038_/Y _1038_/B sky130_fd_sc_hd__nand2_1
X_1107_ VGND VPWR VGND VPWR _1107_/B1 _1107_/A1 _1107_/Y _1107_/A2 sky130_fd_sc_hd__o21ai_0
X_0607_ VGND VPWR VPWR VGND _0607_/X _0607_/B _0607_/A sky130_fd_sc_hd__and2_0
X_0941_ VPWR VGND VGND VPWR _0941_/A _0941_/Y _0941_/B sky130_fd_sc_hd__nand2_1
X_0872_ VPWR VGND VGND VPWR _0872_/A _0872_/Y _0872_/B sky130_fd_sc_hd__nand2_1
X_1286_ VGND VPWR VPWR VGND _1286_/CLK _1286_/D _1286_/RESET_B _1286_/Q sky130_fd_sc_hd__dfrtp_1
X_1140_ VPWR VGND VGND VPWR _1140_/A _1140_/B _1140_/Y sky130_fd_sc_hd__nor2_1
X_1071_ VGND VPWR VGND VPWR _1071_/B1 _1071_/A1 _1071_/Y _1071_/A2 sky130_fd_sc_hd__o21ai_0
X_0924_ VGND VPWR VGND VPWR _0924_/B1 _0924_/A1 _0924_/Y _0924_/A2 sky130_fd_sc_hd__o21ai_0
X_0786_ VGND VPWR VPWR VGND _0786_/Y _0786_/B1 _0786_/C1 _0786_/A1 _0786_/A2 _0786_/B2
+ sky130_fd_sc_hd__a221oi_1
X_0855_ VGND VPWR VGND VPWR _0855_/B1 _0855_/A1 _0855_/Y _0855_/A2 sky130_fd_sc_hd__o21ai_0
X_1269_ VGND VPWR VPWR VGND _1269_/CLK _1269_/D _1269_/RESET_B _1269_/Q sky130_fd_sc_hd__dfrtp_1
X_0640_ VPWR VGND VPWR VGND _0640_/A2 _0640_/A1 _0640_/B1 _0640_/Y sky130_fd_sc_hd__a21oi_1
X_1123_ VPWR VGND VGND VPWR _1123_/A _1123_/Y _1123_/B sky130_fd_sc_hd__nand2_1
X_1054_ VPWR VGND VGND VPWR _1054_/A _1054_/Y _1054_/B sky130_fd_sc_hd__nand2_1
X_0907_ VPWR VGND VGND VPWR _0907_/A _0907_/Y _0907_/B sky130_fd_sc_hd__nand2_1
X_0769_ VGND VPWR VGND VPWR _0769_/B1 _0769_/A1 _0769_/Y _0769_/A2 sky130_fd_sc_hd__o21ai_0
X_0838_ VPWR VGND VPWR VGND _0838_/A _0838_/C _0838_/D _0838_/Y _0838_/B sky130_fd_sc_hd__nand4_1
XPHY_5 VPWR VGND VPWR VGND sky130_fd_sc_hd__decap_3
X_0623_ VPWR VGND VGND VPWR _0623_/A _0623_/B _0623_/Y sky130_fd_sc_hd__nor2_1
X_1106_ VPWR VGND VGND VPWR _1106_/A _1106_/Y _1106_/B sky130_fd_sc_hd__nand2_1
X_1037_ VPWR VGND VGND VPWR _1037_/A _1037_/Y _1037_/B sky130_fd_sc_hd__nand2_1
X_0606_ VPWR VGND VGND VPWR _0606_/C _0606_/B _0606_/A _0606_/Y sky130_fd_sc_hd__nor3_1
X_0940_ VPWR VGND VGND VPWR _0940_/A _0940_/Y _0940_/B sky130_fd_sc_hd__nand2_1
X_0871_ VPWR VGND VGND VPWR _0871_/A _0871_/Y _0871_/B sky130_fd_sc_hd__nand2_1
X_1285_ VGND VPWR VPWR VGND _1285_/CLK _1285_/D _1285_/RESET_B _1285_/Q sky130_fd_sc_hd__dfrtp_1
X_1070_ VPWR VGND VGND VPWR _1070_/A _1070_/Y _1070_/B sky130_fd_sc_hd__nand2_1
X_0923_ VPWR VGND VGND VPWR _0923_/A _0923_/Y _0923_/B sky130_fd_sc_hd__nand2_1
X_0854_ VPWR VGND VGND VPWR _0854_/A _0854_/Y _0854_/B sky130_fd_sc_hd__nand2_1
X_0785_ VPWR VGND VGND VPWR _0785_/A _0785_/Y _0785_/B sky130_fd_sc_hd__nand2_1
X_1268_ VGND VPWR VPWR VGND _1268_/CLK _1268_/D _1268_/RESET_B _1268_/Q sky130_fd_sc_hd__dfrtp_1
X_1199_ VGND VPWR VPWR VGND _1199_/CLK _1199_/D _1199_/RESET_B _1199_/Q sky130_fd_sc_hd__dfrtp_1
X_1122_ VPWR VGND VGND VPWR _1122_/A _1122_/Y _1122_/B sky130_fd_sc_hd__nand2_1
X_1053_ VGND VPWR VGND VPWR _1053_/B1 _1053_/A1 _1053_/Y _1053_/A2 sky130_fd_sc_hd__o21ai_0
X_0837_ VPWR VGND VGND VPWR _0837_/C_N _0837_/B _0837_/Y _0837_/A sky130_fd_sc_hd__nor3b_1
X_0906_ VGND VPWR VGND VPWR _0906_/B1 _0906_/A1 _0906_/Y _0906_/A2 sky130_fd_sc_hd__o21ai_0
X_0768_ VPWR VGND VPWR VGND _0768_/A2 _0768_/A1 _0768_/B1 _0768_/Y sky130_fd_sc_hd__a21oi_1
X_0699_ VGND VPWR VPWR VGND _0699_/C2 _0699_/C1 _0699_/B1 _0699_/A2 _0699_/A1 _0699_/Y
+ _0699_/B2 sky130_fd_sc_hd__a222oi_1
XPHY_6 VPWR VGND VPWR VGND sky130_fd_sc_hd__decap_3
X_0622_ VPWR VGND VGND VPWR _0622_/A _0622_/SLEEP _0622_/X sky130_fd_sc_hd__lpflow_isobufsrc_1
X_1105_ VPWR VGND VGND VPWR _1105_/A _1105_/Y _1105_/B sky130_fd_sc_hd__nand2_1
X_1036_ VPWR VGND VGND VPWR _1036_/A _1036_/Y _1036_/B sky130_fd_sc_hd__nand2_1
X_0605_ VPWR VGND VGND VPWR _0605_/A _0605_/Y _0605_/B sky130_fd_sc_hd__nand2_1
X_1019_ VPWR VGND VGND VPWR _1019_/A _1019_/Y _1019_/B sky130_fd_sc_hd__nand2_1
X_0870_ VGND VPWR VGND VPWR _0870_/B1 _0870_/A1 _0870_/Y _0870_/A2 sky130_fd_sc_hd__o21ai_0
X_1284_ VGND VPWR VPWR VGND _1284_/CLK _1284_/D _1284_/RESET_B _1284_/Q sky130_fd_sc_hd__dfrtp_1
X_0999_ VPWR VGND VGND VPWR _0999_/A _0999_/Y _0999_/B sky130_fd_sc_hd__nand2_1
X_0922_ VPWR VGND VGND VPWR _0922_/A _0922_/Y _0922_/B sky130_fd_sc_hd__nand2_1
X_0853_ VPWR VGND VGND VPWR _0853_/A _0853_/Y _0853_/B sky130_fd_sc_hd__nand2_1
X_0784_ VGND VPWR VGND VPWR _0784_/B1 _0784_/A1 _0784_/Y _0784_/A2 sky130_fd_sc_hd__o21ai_0
X_1198_ VGND VPWR VPWR VGND _1198_/CLK _1198_/D _1198_/RESET_B _1198_/Q sky130_fd_sc_hd__dfrtp_1
X_1267_ VGND VPWR VPWR VGND _1267_/CLK _1267_/D _1267_/RESET_B _1267_/Q sky130_fd_sc_hd__dfrtp_1
X_1121_ VPWR VGND VGND VPWR _1121_/A _1121_/Y _1121_/B sky130_fd_sc_hd__nand2_1
X_1052_ VPWR VGND VGND VPWR _1052_/A _1052_/Y _1052_/B sky130_fd_sc_hd__nand2_1
X_0767_ VGND VPWR VPWR VGND _0767_/A _0767_/X _0767_/B sky130_fd_sc_hd__xor2_1
X_0905_ VPWR VGND VGND VPWR _0905_/A _0905_/Y _0905_/B sky130_fd_sc_hd__nand2_1
X_0836_ VPWR VGND VPWR VGND _0836_/A _0836_/C _0836_/D _0836_/Y _0836_/B sky130_fd_sc_hd__nand4_1
X_0698_ VPWR VGND VPWR VGND _0698_/B2 _0698_/B1 _0698_/Y _0698_/A1 _0698_/A2 sky130_fd_sc_hd__a22oi_1
X_1319_ _1319_/LO _1319_/HI VPWR VGND VGND VPWR sky130_fd_sc_hd__conb_1
XPHY_7 VPWR VGND VPWR VGND sky130_fd_sc_hd__decap_3
X_0621_ VPWR VGND VGND VPWR _0621_/A _0621_/SLEEP _0621_/X sky130_fd_sc_hd__lpflow_isobufsrc_1
X_1104_ VPWR VGND VGND VPWR _1104_/A _1104_/Y _1104_/B sky130_fd_sc_hd__nand2_1
X_1035_ VGND VPWR VGND VPWR _1035_/B1 _1035_/A1 _1035_/Y _1035_/A2 sky130_fd_sc_hd__o21ai_0
X_0819_ VPWR VGND VPWR VGND _0819_/A _0819_/C _0819_/D _0819_/Y _0819_/B sky130_fd_sc_hd__nand4_1
X_0604_ VPWR VGND VPWR VGND _0604_/A2 _0604_/A1 _0604_/B1 _0604_/Y sky130_fd_sc_hd__a21oi_1
X_1018_ VPWR VGND VGND VPWR _1018_/A _1018_/Y _1018_/B sky130_fd_sc_hd__nand2_1
X_1283_ VGND VPWR VPWR VGND _1283_/CLK _1283_/D _1283_/RESET_B _1283_/Q sky130_fd_sc_hd__dfrtp_1
X_0998_ VPWR VGND VGND VPWR _0998_/A _0998_/Y _0998_/B sky130_fd_sc_hd__nand2_1
X_0921_ VPWR VGND VGND VPWR _0921_/A _0921_/Y _0921_/B sky130_fd_sc_hd__nand2_1
X_0783_ VPWR VGND VGND VPWR _0783_/A _0783_/Y _0783_/B sky130_fd_sc_hd__nand2_1
X_0852_ VGND VPWR VGND VPWR _0852_/B1 _0852_/A1 _0852_/Y _0852_/A2 sky130_fd_sc_hd__o21ai_0
X_1197_ VGND VPWR VPWR VGND _1197_/CLK _1197_/D _1197_/RESET_B _1197_/Q sky130_fd_sc_hd__dfrtp_1
X_1266_ VGND VPWR VPWR VGND _1266_/CLK _1266_/D _1266_/RESET_B _1266_/Q sky130_fd_sc_hd__dfrtp_1
X_1120_ VPWR VGND VGND VPWR _1120_/A _1120_/Y _1120_/B sky130_fd_sc_hd__nand2_1
X_1051_ VPWR VGND VGND VPWR _1051_/A _1051_/Y _1051_/B sky130_fd_sc_hd__nand2_1
X_0904_ VPWR VGND VGND VPWR _0904_/A _0904_/Y _0904_/B sky130_fd_sc_hd__nand2_1
X_0766_ VPWR VGND VPWR VGND _0766_/A2 _0766_/A1 _0766_/B1 _0766_/Y sky130_fd_sc_hd__a21oi_1
X_0835_ VPWR VGND VGND VPWR _0835_/Y _0835_/D _0835_/C _0835_/B _0835_/A sky130_fd_sc_hd__nor4_1
X_0697_ VPWR VGND VPWR VGND _0697_/B2 _0697_/B1 _0697_/Y _0697_/A1 _0697_/A2 sky130_fd_sc_hd__a22oi_1
X_1318_ _1318_/LO _1318_/HI VPWR VGND VGND VPWR sky130_fd_sc_hd__conb_1
X_1249_ VGND VPWR VPWR VGND _1249_/CLK _1249_/D _1249_/RESET_B _1249_/Q sky130_fd_sc_hd__dfrtp_1
XPHY_8 VPWR VGND VPWR VGND sky130_fd_sc_hd__decap_3
X_0620_ VPWR VGND VGND VPWR _0620_/A_N _0620_/B _0620_/Y sky130_fd_sc_hd__nand2b_1
X_1034_ VPWR VGND VGND VPWR _1034_/A _1034_/Y _1034_/B sky130_fd_sc_hd__nand2_1
X_1103_ VPWR VGND VGND VPWR _1103_/A _1103_/Y _1103_/B sky130_fd_sc_hd__nand2_1
X_0818_ VPWR VGND VPWR VGND _0818_/A _0818_/C _0818_/D _0818_/Y _0818_/B sky130_fd_sc_hd__nand4_1
X_0749_ VGND VPWR VPWR VGND _0749_/C2 _0749_/C1 _0749_/B1 _0749_/A2 _0749_/A1 _0749_/Y
+ _0749_/B2 sky130_fd_sc_hd__a222oi_1
X_0603_ VGND VPWR _0603_/X _0603_/B _0603_/A _0603_/C VPWR VGND sky130_fd_sc_hd__and3_1
X_1017_ VGND VPWR VGND VPWR _1017_/B1 _1017_/A1 _1017_/Y _1017_/A2 sky130_fd_sc_hd__o21ai_0
X_1282_ VGND VPWR VPWR VGND _1282_/CLK _1282_/D _1282_/RESET_B _1282_/Q sky130_fd_sc_hd__dfrtp_1
X_0997_ VPWR VGND VGND VPWR _0997_/A _0997_/Y _0997_/B sky130_fd_sc_hd__nand2_1
X_0920_ VPWR VGND VGND VPWR _0920_/A _0920_/Y _0920_/B sky130_fd_sc_hd__nand2_1
X_0782_ VPWR VGND VGND VPWR _0782_/A _0782_/B _0782_/Y sky130_fd_sc_hd__nor2_1
X_0851_ VPWR VGND VGND VPWR _0851_/A _0851_/Y _0851_/B sky130_fd_sc_hd__nand2_1
X_1265_ VGND VPWR VPWR VGND _1265_/CLK _1265_/D _1265_/RESET_B _1265_/Q sky130_fd_sc_hd__dfrtp_1
X_1196_ VGND VPWR VPWR VGND _1196_/CLK _1196_/D _1196_/RESET_B _1196_/Q sky130_fd_sc_hd__dfrtp_1
X_1050_ VPWR VGND VGND VPWR _1050_/A _1050_/Y _1050_/B sky130_fd_sc_hd__nand2_1
X_0903_ VGND VPWR VGND VPWR _0903_/B1 _0903_/A1 _0903_/Y _0903_/A2 sky130_fd_sc_hd__o21ai_0
X_0834_ VPWR VGND VPWR VGND _0834_/A _0834_/C _0834_/D _0834_/Y _0834_/B sky130_fd_sc_hd__nand4_1
X_0765_ VPWR VGND VGND VPWR _0765_/A _0765_/Y _0765_/B sky130_fd_sc_hd__nand2_1
X_0696_ VPWR VGND VGND VPWR _0696_/C _0696_/B _0696_/A _0696_/Y sky130_fd_sc_hd__nor3_1
X_1317_ _1317_/LO _1317_/HI VPWR VGND VGND VPWR sky130_fd_sc_hd__conb_1
X_1248_ VGND VPWR VPWR VGND _1248_/CLK _1248_/D _1248_/RESET_B _1248_/Q sky130_fd_sc_hd__dfrtp_1
X_1179_ VGND VPWR VPWR VGND _1179_/CLK _1179_/D _1179_/RESET_B _1179_/Q sky130_fd_sc_hd__dfrtp_1
XPHY_9 VPWR VGND VPWR VGND sky130_fd_sc_hd__decap_3
X_1102_ VPWR VGND VGND VPWR _1102_/A _1102_/Y _1102_/B sky130_fd_sc_hd__nand2_1
X_1033_ VPWR VGND VGND VPWR _1033_/A _1033_/Y _1033_/B sky130_fd_sc_hd__nand2_1
X_0817_ VPWR VGND VGND VPWR _0817_/A _0817_/B _0817_/Y _0817_/C sky130_fd_sc_hd__nand3_1
X_0679_ VPWR VGND VGND VPWR _0679_/A_N _0679_/B _0679_/Y sky130_fd_sc_hd__nand2b_1
X_0748_ VPWR VGND VPWR VGND _0748_/B2 _0748_/B1 _0748_/Y _0748_/A1 _0748_/A2 sky130_fd_sc_hd__a22oi_1
X_0602_ VPWR VGND VGND VPWR _0602_/A _0602_/Y _0602_/B sky130_fd_sc_hd__nand2_1
X_1016_ VPWR VGND VGND VPWR _1016_/A _1016_/Y _1016_/B sky130_fd_sc_hd__nand2_1
X_1281_ VGND VPWR VPWR VGND _1281_/CLK _1281_/D _1281_/RESET_B _1281_/Q sky130_fd_sc_hd__dfrtp_1
X_0996_ VPWR VGND VGND VPWR _0996_/A _0996_/Y _0996_/B sky130_fd_sc_hd__nand2_1
X_0850_ VPWR VGND VGND VPWR _0850_/A _0850_/Y _0850_/B sky130_fd_sc_hd__nand2_1
X_0781_ VPWR VGND VPWR VGND _0781_/A2 _0781_/A1 _0781_/B1 _0781_/Y sky130_fd_sc_hd__a21oi_1
X_1264_ VGND VPWR VPWR VGND _1264_/CLK _1264_/D _1264_/RESET_B _1264_/Q sky130_fd_sc_hd__dfrtp_1
X_1195_ VGND VPWR VPWR VGND _1195_/CLK _1195_/D _1195_/RESET_B _1195_/Q sky130_fd_sc_hd__dfrtp_1
X_0979_ VPWR VGND VGND VPWR _0979_/A _0979_/Y _0979_/B sky130_fd_sc_hd__nand2_1
X_0902_ VPWR VGND VGND VPWR _0902_/A _0902_/Y _0902_/B sky130_fd_sc_hd__nand2_1
X_0833_ VPWR VGND VGND VPWR _0833_/Y _0833_/D _0833_/C _0833_/B _0833_/A sky130_fd_sc_hd__nor4_1
X_0695_ VPWR VGND VGND VPWR _0695_/C _0695_/B _0695_/A _0695_/Y sky130_fd_sc_hd__nor3_1
X_0764_ VPWR VGND VPWR VGND _0764_/A2 _0764_/A1 _0764_/B1 _0764_/X sky130_fd_sc_hd__a21o_1
X_1316_ _1316_/LO _1316_/HI VPWR VGND VGND VPWR sky130_fd_sc_hd__conb_1
X_1178_ VGND VPWR VPWR VGND _1178_/CLK _1178_/D _1178_/RESET_B _1178_/Q sky130_fd_sc_hd__dfrtp_1
X_1247_ VGND VPWR VPWR VGND _1247_/CLK _1247_/D _1247_/RESET_B _1247_/Q sky130_fd_sc_hd__dfrtp_1
X_1101_ VGND VPWR VGND VPWR _1101_/B1 _1101_/A1 _1101_/Y _1101_/A2 sky130_fd_sc_hd__o21ai_0
X_1032_ VGND VPWR VGND VPWR _1032_/B1 _1032_/A1 _1032_/Y _1032_/A2 sky130_fd_sc_hd__o21ai_0
X_0816_ VPWR VGND VGND VPWR _0816_/A _0816_/B _0816_/Y sky130_fd_sc_hd__nor2_1
X_0747_ VGND VPWR VPWR VGND _0747_/C2 _0747_/C1 _0747_/B1 _0747_/A2 _0747_/A1 _0747_/Y
+ _0747_/B2 sky130_fd_sc_hd__a222oi_1
X_0678_ VPWR VGND VGND VPWR _0678_/A _0678_/Y _0678_/B sky130_fd_sc_hd__nand2_1
X_0601_ VPWR VGND VGND VPWR _0601_/A _0601_/Y _0601_/B sky130_fd_sc_hd__nand2_1
X_1015_ VPWR VGND VGND VPWR _1015_/A _1015_/Y _1015_/B sky130_fd_sc_hd__nand2_1
X_1280_ VGND VPWR VPWR VGND _1280_/CLK _1280_/D _1280_/RESET_B _1280_/Q sky130_fd_sc_hd__dfrtp_1
X_0995_ VPWR VGND VGND VPWR _0995_/A _0995_/Y _0995_/B sky130_fd_sc_hd__nand2_1
X_0780_ VGND VPWR VGND VPWR _0780_/B1 _0780_/A1 _0780_/Y _0780_/A2 sky130_fd_sc_hd__o21ai_0
X_1194_ VGND VPWR VPWR VGND _1194_/CLK _1194_/D _1194_/RESET_B _1194_/Q sky130_fd_sc_hd__dfrtp_1
X_1263_ VGND VPWR VPWR VGND _1263_/CLK _1263_/D _1263_/RESET_B _1263_/Q sky130_fd_sc_hd__dfrtp_1
X_0978_ VGND VPWR VGND VPWR _0978_/B1 _0978_/A1 _0978_/Y _0978_/A2 sky130_fd_sc_hd__o21ai_0
X_0901_ VPWR VGND VGND VPWR _0901_/A _0901_/Y _0901_/B sky130_fd_sc_hd__nand2_1
X_0763_ VPWR VGND VPWR VGND _0763_/A2 _0763_/A1 _0763_/B1 _0763_/Y sky130_fd_sc_hd__a21oi_1
X_0832_ VPWR VGND VGND VPWR _0832_/A _0832_/Y _0832_/B sky130_fd_sc_hd__nand2_1
X_1315_ _1315_/LO _1315_/HI VPWR VGND VGND VPWR sky130_fd_sc_hd__conb_1
X_0694_ VPWR VGND VGND VPWR _0694_/A _0694_/B _0694_/Y sky130_fd_sc_hd__nor2_1
X_1177_ VGND VPWR VPWR VGND _1177_/CLK _1177_/D _1177_/RESET_B _1177_/Q sky130_fd_sc_hd__dfrtp_1
X_1246_ VGND VPWR VPWR VGND _1246_/CLK _1246_/D _1246_/RESET_B _1246_/Q sky130_fd_sc_hd__dfrtp_1
Xclkbuf_4_9_0_clk VGND VPWR clkbuf_4_9_0_clk/A clkbuf_4_9_0_clk/X VPWR VGND sky130_fd_sc_hd__clkbuf_2
X_1031_ VPWR VGND VGND VPWR _1031_/A _1031_/Y _1031_/B sky130_fd_sc_hd__nand2_1
X_1100_ VPWR VGND VGND VPWR _1100_/A _1100_/Y _1100_/B sky130_fd_sc_hd__nand2_1
X_0746_ VPWR VGND VGND VPWR _0746_/A _0746_/Y _0746_/B sky130_fd_sc_hd__nand2_1
X_0815_ VPWR VGND VGND VPWR _0815_/D_N _0815_/C _0815_/Y _0815_/B _0815_/A sky130_fd_sc_hd__nor4b_1
X_0677_ VPWR VGND VGND VPWR _0677_/A _0677_/Y _0677_/B sky130_fd_sc_hd__nand2_1
X_1229_ VGND VPWR VPWR VGND _1229_/CLK _1229_/D _1229_/RESET_B _1229_/Q sky130_fd_sc_hd__dfrtp_1
X_0600_ VGND VPWR VPWR VGND _0600_/A _0600_/X _0600_/B sky130_fd_sc_hd__xor2_1
X_1014_ VGND VPWR VGND VPWR _1014_/B1 _1014_/A1 _1014_/Y _1014_/A2 sky130_fd_sc_hd__o21ai_0
X_0729_ VGND VPWR VPWR VGND _0729_/C2 _0729_/C1 _0729_/B1 _0729_/A2 _0729_/A1 _0729_/Y
+ _0729_/B2 sky130_fd_sc_hd__a222oi_1
X_0994_ VPWR VGND VGND VPWR _0994_/A _0994_/Y _0994_/B sky130_fd_sc_hd__nand2_1
X_1262_ VGND VPWR VPWR VGND _1262_/CLK _1262_/D _1262_/RESET_B _1262_/Q sky130_fd_sc_hd__dfrtp_1
X_1193_ VGND VPWR VPWR VGND _1193_/CLK _1193_/D _1193_/RESET_B _1193_/Q sky130_fd_sc_hd__dfrtp_1
X_0977_ VPWR VGND VGND VPWR _0977_/A _0977_/Y _0977_/B sky130_fd_sc_hd__nand2_1
X_0900_ VGND VPWR VGND VPWR _0900_/B1 _0900_/A1 _0900_/Y _0900_/A2 sky130_fd_sc_hd__o21ai_0
X_0762_ VGND VPWR _0762_/B _0762_/Y _0762_/A VPWR VGND sky130_fd_sc_hd__xnor2_1
X_0831_ VPWR VGND VGND VPWR _0831_/A _0831_/Y _0831_/B sky130_fd_sc_hd__nand2_1
X_0693_ VPWR VGND VGND VPWR _0693_/A _0693_/B _0693_/Y sky130_fd_sc_hd__nor2_1
X_1314_ _1314_/LO _1314_/HI VPWR VGND VGND VPWR sky130_fd_sc_hd__conb_1
X_1176_ VGND VPWR VPWR VGND _1176_/CLK _1176_/D _1176_/RESET_B _1176_/Q sky130_fd_sc_hd__dfrtp_1
X_1245_ VGND VPWR VPWR VGND _1245_/CLK _1245_/D _1245_/RESET_B _1245_/Q sky130_fd_sc_hd__dfrtp_1
X_1030_ VPWR VGND VGND VPWR _1030_/A _1030_/Y _1030_/B sky130_fd_sc_hd__nand2_1
X_0814_ VPWR VGND VGND VPWR _0814_/C _0814_/B _0814_/A _0814_/Y sky130_fd_sc_hd__nor3_1
X_0745_ VPWR VGND VGND VPWR _0745_/A _0745_/B _0745_/Y sky130_fd_sc_hd__nor2_1
X_0676_ VPWR VGND VGND VPWR _0676_/A _0676_/B _0676_/Y _0676_/C sky130_fd_sc_hd__nand3_1
X_1228_ VGND VPWR VPWR VGND _1228_/CLK _1228_/D _1228_/RESET_B _1228_/Q sky130_fd_sc_hd__dfrtp_1
X_1159_ VPWR VGND VPWR VGND _1159_/A2 _1159_/A1 _1159_/B1 _1159_/Y sky130_fd_sc_hd__a21oi_1
X_1013_ VPWR VGND VGND VPWR _1013_/A _1013_/Y _1013_/B sky130_fd_sc_hd__nand2_1
X_0659_ VPWR VGND VGND VPWR _0659_/A _0659_/B _0659_/Y sky130_fd_sc_hd__nor2_1
X_0728_ VGND VPWR VPWR VGND _0728_/C2 _0728_/C1 _0728_/B1 _0728_/A2 _0728_/A1 _0728_/Y
+ _0728_/B2 sky130_fd_sc_hd__a222oi_1
Xclkbuf_4_8_0_clk VGND VPWR clkbuf_4_8_0_clk/A clkbuf_4_8_0_clk/X VPWR VGND sky130_fd_sc_hd__clkbuf_2
X_0993_ VPWR VGND VGND VPWR _0993_/A _0993_/Y _0993_/B sky130_fd_sc_hd__nand2_1
X_1261_ VGND VPWR VPWR VGND _1261_/CLK _1261_/D _1261_/RESET_B _1261_/Q sky130_fd_sc_hd__dfrtp_1
X_1192_ VGND VPWR VPWR VGND _1192_/CLK _1192_/D _1192_/RESET_B _1192_/Q sky130_fd_sc_hd__dfrtp_1
X_0976_ VPWR VGND VGND VPWR _0976_/A _0976_/Y _0976_/B sky130_fd_sc_hd__nand2_1
X_0830_ VPWR VGND VGND VPWR _0830_/Y _0830_/D _0830_/C _0830_/B _0830_/A sky130_fd_sc_hd__nor4_1
X_0692_ VPWR VGND VGND VPWR _0692_/C _0692_/B _0692_/A _0692_/Y sky130_fd_sc_hd__nor3_1
X_0761_ VPWR VGND VPWR VGND _0761_/A2 _0761_/A1 _0761_/B1 _0761_/Y sky130_fd_sc_hd__a21oi_1
X_1313_ _1313_/LO _1313_/HI VPWR VGND VGND VPWR sky130_fd_sc_hd__conb_1
X_1244_ VGND VPWR VPWR VGND _1244_/CLK _1244_/D _1244_/RESET_B _1244_/Q sky130_fd_sc_hd__dfrtp_1
X_1175_ VGND VPWR VPWR VGND _1175_/CLK _1175_/D _1175_/RESET_B _1175_/Q sky130_fd_sc_hd__dfrtp_1
X_0959_ VPWR VGND VGND VPWR _0959_/A _0959_/Y _0959_/B sky130_fd_sc_hd__nand2_1
X_0813_ VPWR VGND VGND VPWR _0813_/A _0813_/Y _0813_/B sky130_fd_sc_hd__nand2_1
X_0675_ VPWR VGND VGND VPWR _0675_/A _0675_/SLEEP _0675_/X sky130_fd_sc_hd__lpflow_isobufsrc_1
X_0744_ VGND VPWR VPWR VGND _0744_/Y _0744_/B1 _0744_/C1 _0744_/A1 _0744_/A2 _0744_/B2
+ sky130_fd_sc_hd__a221oi_1
X_1158_ VPWR VGND VPWR VGND _1158_/A2 _1158_/A1 _1158_/B1 _1158_/X sky130_fd_sc_hd__a21o_1
X_1227_ VGND VPWR VPWR VGND _1227_/CLK _1227_/D _1227_/RESET_B _1227_/Q sky130_fd_sc_hd__dfrtp_1
X_1089_ VGND VPWR VGND VPWR _1089_/B1 _1089_/A1 _1089_/Y _1089_/A2 sky130_fd_sc_hd__o21ai_0
X_1012_ VPWR VGND VGND VPWR _1012_/A _1012_/Y _1012_/B sky130_fd_sc_hd__nand2_1
X_0727_ VPWR VGND VPWR VGND _0727_/B2 _0727_/B1 _0727_/Y _0727_/A1 _0727_/A2 sky130_fd_sc_hd__a22oi_1
X_0658_ VPWR VGND VGND VPWR _0658_/A _0658_/B _0658_/Y sky130_fd_sc_hd__nor2_1
X_0589_ VPWR VGND VGND VPWR _0589_/A _0589_/SLEEP _0589_/X sky130_fd_sc_hd__lpflow_isobufsrc_1
X_0992_ VPWR VGND VGND VPWR _0992_/A _0992_/Y _0992_/B sky130_fd_sc_hd__nand2_1
Xclkbuf_4_7_0_clk VGND VPWR clkbuf_4_7_0_clk/A clkbuf_4_7_0_clk/X VPWR VGND sky130_fd_sc_hd__clkbuf_2
X_1260_ VGND VPWR VPWR VGND _1260_/CLK _1260_/D _1260_/RESET_B _1260_/Q sky130_fd_sc_hd__dfrtp_1
X_1191_ VGND VPWR VPWR VGND _1191_/CLK _1191_/D _1191_/RESET_B _1191_/Q sky130_fd_sc_hd__dfrtp_1
X_0975_ VPWR VGND VGND VPWR _0975_/A _0975_/Y _0975_/B sky130_fd_sc_hd__nand2_1
XPHY_70 VPWR VGND VPWR VGND sky130_fd_sc_hd__decap_3
X_0760_ VPWR VGND VGND VPWR _0760_/X _0760_/SLEEP _0760_/A sky130_fd_sc_hd__lpflow_inputiso1p_1
X_0691_ VPWR VGND VGND VPWR _0691_/C _0691_/B _0691_/A _0691_/Y sky130_fd_sc_hd__nor3_1
X_1312_ _1312_/LO _1312_/HI VPWR VGND VGND VPWR sky130_fd_sc_hd__conb_1
X_1174_ VGND VPWR VPWR VGND _1174_/CLK _1174_/D _1174_/RESET_B _1174_/Q sky130_fd_sc_hd__dfrtp_1
X_1243_ VGND VPWR VPWR VGND _1243_/CLK _1243_/D _1243_/RESET_B _1243_/Q sky130_fd_sc_hd__dfrtp_1
X_0958_ VPWR VGND VGND VPWR _0958_/A _0958_/Y _0958_/B sky130_fd_sc_hd__nand2_1
X_0889_ VPWR VGND VGND VPWR _0889_/A _0889_/Y _0889_/B sky130_fd_sc_hd__nand2_1
X_0812_ VPWR VGND VGND VPWR _0812_/Y _0812_/D _0812_/C _0812_/B _0812_/A sky130_fd_sc_hd__nor4_1
X_0743_ VPWR VGND VPWR VGND _0743_/A _0743_/C _0743_/D _0743_/Y _0743_/B sky130_fd_sc_hd__nand4_1
X_0674_ VGND VPWR VGND VPWR _0674_/B1 _0674_/A1 _0674_/Y _0674_/A2 sky130_fd_sc_hd__o21ai_0
X_1157_ VPWR VGND VGND VPWR _1157_/C _1157_/B _1157_/A _1157_/Y sky130_fd_sc_hd__nor3_1
X_1226_ VGND VPWR VPWR VGND _1226_/CLK _1226_/D _1226_/RESET_B _1226_/Q sky130_fd_sc_hd__dfrtp_1
X_1088_ VPWR VGND VGND VPWR _1088_/A _1088_/Y _1088_/B sky130_fd_sc_hd__nand2_1
X_1011_ VGND VPWR VGND VPWR _1011_/B1 _1011_/A1 _1011_/Y _1011_/A2 sky130_fd_sc_hd__o21ai_0
X_0726_ VGND VPWR VPWR VGND _0726_/C2 _0726_/C1 _0726_/B1 _0726_/A2 _0726_/A1 _0726_/Y
+ _0726_/B2 sky130_fd_sc_hd__a222oi_1
X_0657_ VPWR VGND VGND VPWR _0657_/A _0657_/B _0657_/Y sky130_fd_sc_hd__nor2_1
X_0588_ VPWR VGND VGND VPWR _0588_/A_N _0588_/B _0588_/Y sky130_fd_sc_hd__nand2b_1
X_1209_ VGND VPWR VPWR VGND _1209_/CLK _1209_/D _1209_/RESET_B _1209_/Q sky130_fd_sc_hd__dfrtp_1
X_0709_ VGND VPWR VPWR VGND _0709_/Y _0709_/B1 _0709_/C1 _0709_/A1 _0709_/A2 _0709_/B2
+ sky130_fd_sc_hd__a221oi_1
X_0991_ VPWR VGND VGND VPWR _0991_/A _0991_/Y _0991_/B sky130_fd_sc_hd__nand2_1
X_1190_ VPWR VGND VPWR VGND _1190_/Q _1190_/SET_B _1190_/D _1190_/CLK sky130_fd_sc_hd__dfstp_2
X_0974_ VPWR VGND VGND VPWR _0974_/A _0974_/Y _0974_/B sky130_fd_sc_hd__nand2_1
XPHY_71 VPWR VGND VPWR VGND sky130_fd_sc_hd__decap_3
XPHY_60 VPWR VGND VPWR VGND sky130_fd_sc_hd__decap_3
Xclkbuf_4_6_0_clk VGND VPWR clkbuf_4_6_0_clk/A clkbuf_4_6_0_clk/X VPWR VGND sky130_fd_sc_hd__clkbuf_2
X_0690_ VPWR VGND VGND VPWR _0690_/C _0690_/B _0690_/A _0690_/Y sky130_fd_sc_hd__nor3_1
X_1311_ VGND VPWR VPWR VGND _1311_/CLK _1311_/D _1311_/RESET_B _1311_/Q sky130_fd_sc_hd__dfrtp_1
X_1173_ VGND VPWR VPWR VGND _1173_/CLK _1173_/D _1173_/RESET_B _1173_/Q sky130_fd_sc_hd__dfrtp_1
X_1242_ VGND VPWR VPWR VGND _1242_/CLK _1242_/D _1242_/RESET_B _1242_/Q sky130_fd_sc_hd__dfrtp_1
X_0888_ VGND VPWR VGND VPWR _0888_/B1 _0888_/A1 _0888_/Y _0888_/A2 sky130_fd_sc_hd__o21ai_0
X_0957_ VPWR VGND VGND VPWR _0957_/A _0957_/Y _0957_/B sky130_fd_sc_hd__nand2_1
X_0673_ VGND VPWR VPWR VGND _0673_/B2 _0673_/Y _0673_/B1 _0673_/A1 _0673_/A2 _0673_/A3
+ sky130_fd_sc_hd__a32oi_1
X_0742_ VGND VPWR VPWR VGND _0742_/C2 _0742_/C1 _0742_/B1 _0742_/A2 _0742_/A1 _0742_/Y
+ _0742_/B2 sky130_fd_sc_hd__a222oi_1
X_0811_ VPWR VGND VGND VPWR _0811_/A _0811_/Y _0811_/B sky130_fd_sc_hd__nand2_1
X_1156_ VPWR VGND VPWR VGND _1156_/A2 _1156_/A1 _1156_/B1 _1156_/Y sky130_fd_sc_hd__a21oi_1
X_1225_ VGND VPWR VPWR VGND _1225_/CLK _1225_/D _1225_/RESET_B _1225_/Q sky130_fd_sc_hd__dfrtp_1
X_1087_ VPWR VGND VGND VPWR _1087_/A _1087_/Y _1087_/B sky130_fd_sc_hd__nand2_1
X_1010_ VPWR VGND VGND VPWR _1010_/A _1010_/Y _1010_/B sky130_fd_sc_hd__nand2_1
X_0656_ VPWR VGND VGND VPWR _0656_/A _0656_/Y sky130_fd_sc_hd__clkinv_1
X_0725_ VPWR VGND VGND VPWR _0725_/A _0725_/Y _0725_/B sky130_fd_sc_hd__nand2_1
X_0587_ VPWR VGND VPWR VGND _0587_/A2 _0587_/A1 _0587_/B1 _0587_/Y sky130_fd_sc_hd__a21oi_1
X_1208_ VGND VPWR VPWR VGND _1208_/CLK _1208_/D _1208_/RESET_B _1208_/Q sky130_fd_sc_hd__dfrtp_1
X_1139_ VPWR VGND VGND VPWR _1139_/A _1139_/B _1139_/Y sky130_fd_sc_hd__nor2_1
X_0639_ VPWR VGND VGND VPWR _0639_/A _0639_/B _0639_/Y sky130_fd_sc_hd__nor2_1
X_0708_ VPWR VGND VPWR VGND _0708_/A _0708_/C _0708_/D _0708_/Y _0708_/B sky130_fd_sc_hd__nand4_1
X_0990_ VGND VPWR VGND VPWR _0990_/B1 _0990_/A1 _0990_/Y _0990_/A2 sky130_fd_sc_hd__o21ai_0
X_0973_ VPWR VGND VGND VPWR _0973_/A _0973_/Y _0973_/B sky130_fd_sc_hd__nand2_1
XPHY_72 VPWR VGND VPWR VGND sky130_fd_sc_hd__decap_3
XPHY_61 VPWR VGND VPWR VGND sky130_fd_sc_hd__decap_3
XPHY_50 VPWR VGND VPWR VGND sky130_fd_sc_hd__decap_3
X_1241_ VGND VPWR VPWR VGND _1241_/CLK _1241_/D _1241_/RESET_B _1241_/Q sky130_fd_sc_hd__dfrtp_1
X_1310_ VGND VPWR VPWR VGND _1310_/CLK _1310_/D _1310_/RESET_B _1310_/Q sky130_fd_sc_hd__dfrtp_1
X_1172_ VGND VPWR VPWR VGND _1172_/CLK _1172_/D _1172_/RESET_B _1172_/Q sky130_fd_sc_hd__dfrtp_1
X_0956_ VPWR VGND VGND VPWR _0956_/A _0956_/Y _0956_/B sky130_fd_sc_hd__nand2_1
X_0887_ VPWR VGND VGND VPWR _0887_/A _0887_/Y _0887_/B sky130_fd_sc_hd__nand2_1
X_0810_ VPWR VGND VGND VPWR _0810_/A _0810_/B _0810_/Y _0810_/C sky130_fd_sc_hd__nand3_1
X_0672_ VGND VPWR VGND VPWR _0672_/B1 _0672_/A1 _0672_/Y _0672_/A2 sky130_fd_sc_hd__o21ai_0
X_0741_ VGND VPWR VPWR VGND _0741_/C2 _0741_/C1 _0741_/B1 _0741_/A2 _0741_/A1 _0741_/Y
+ _0741_/B2 sky130_fd_sc_hd__a222oi_1
X_1224_ VGND VPWR VPWR VGND _1224_/CLK _1224_/D _1224_/RESET_B _1224_/Q sky130_fd_sc_hd__dfrtp_1
X_1155_ VPWR VGND VGND VPWR _1155_/A _1155_/Y sky130_fd_sc_hd__clkinv_1
X_1086_ VPWR VGND VGND VPWR _1086_/A _1086_/Y _1086_/B sky130_fd_sc_hd__nand2_1
X_0939_ VPWR VGND VGND VPWR _0939_/A _0939_/Y _0939_/B sky130_fd_sc_hd__nand2_1
Xclkbuf_4_5_0_clk VGND VPWR clkbuf_4_5_0_clk/A clkbuf_4_5_0_clk/X VPWR VGND sky130_fd_sc_hd__clkbuf_2
X_0586_ VPWR VGND VGND VPWR _0586_/A _0586_/SLEEP _0586_/X sky130_fd_sc_hd__lpflow_isobufsrc_1
X_0655_ VGND VPWR _0655_/X _0655_/B _0655_/A _0655_/C VPWR VGND sky130_fd_sc_hd__and3_1
X_0724_ VGND VPWR VPWR VGND _0724_/A3 _0724_/A2 _0724_/A1 _0724_/Y _0724_/B1 sky130_fd_sc_hd__a31oi_1
X_1207_ VGND VPWR VPWR VGND _1207_/CLK _1207_/D _1207_/RESET_B _1207_/Q sky130_fd_sc_hd__dfrtp_1
X_1138_ VPWR VGND VGND VPWR _1138_/A _1138_/B _1138_/Y sky130_fd_sc_hd__nor2_1
X_1069_ VPWR VGND VGND VPWR _1069_/A _1069_/Y _1069_/B sky130_fd_sc_hd__nand2_1
X_0707_ VGND VPWR VPWR VGND _0707_/C2 _0707_/C1 _0707_/B1 _0707_/A2 _0707_/A1 _0707_/Y
+ _0707_/B2 sky130_fd_sc_hd__a222oi_1
X_0638_ VGND VPWR VGND VPWR _0638_/B1 _0638_/A1 _0638_/Y _0638_/A2 sky130_fd_sc_hd__o21ai_0
X_0972_ VPWR VGND VGND VPWR _0972_/A _0972_/Y _0972_/B sky130_fd_sc_hd__nand2_1
XPHY_73 VPWR VGND VPWR VGND sky130_fd_sc_hd__decap_3
XPHY_62 VPWR VGND VPWR VGND sky130_fd_sc_hd__decap_3
XPHY_51 VPWR VGND VPWR VGND sky130_fd_sc_hd__decap_3
XPHY_40 VPWR VGND VPWR VGND sky130_fd_sc_hd__decap_3
X_1171_ VGND VPWR VPWR VGND _1171_/CLK _1171_/D _1171_/RESET_B _1171_/Q sky130_fd_sc_hd__dfrtp_1
X_1240_ VGND VPWR VPWR VGND _1240_/CLK _1240_/D _1240_/RESET_B _1240_/Q sky130_fd_sc_hd__dfrtp_1
X_0886_ VPWR VGND VGND VPWR _0886_/A _0886_/Y _0886_/B sky130_fd_sc_hd__nand2_1
X_0955_ VPWR VGND VGND VPWR _0955_/A _0955_/Y _0955_/B sky130_fd_sc_hd__nand2_1
X_0740_ VPWR VGND VPWR VGND _0740_/B2 _0740_/B1 _0740_/Y _0740_/A1 _0740_/A2 sky130_fd_sc_hd__a22oi_1
X_0671_ VPWR VGND VGND VPWR _0671_/A _0671_/Y _0671_/B sky130_fd_sc_hd__nand2_1
X_1154_ VPWR VGND VPWR VGND _1154_/A _1154_/C _1154_/D _1154_/Y _1154_/B sky130_fd_sc_hd__nand4_1
X_1223_ VGND VPWR VPWR VGND _1223_/CLK _1223_/D _1223_/RESET_B _1223_/Q sky130_fd_sc_hd__dfrtp_1
X_1085_ VPWR VGND VGND VPWR _1085_/A _1085_/Y _1085_/B sky130_fd_sc_hd__nand2_1
X_0869_ VPWR VGND VGND VPWR _0869_/A _0869_/Y _0869_/B sky130_fd_sc_hd__nand2_1
X_0938_ VPWR VGND VGND VPWR _0938_/A _0938_/Y _0938_/B sky130_fd_sc_hd__nand2_1
X_0723_ VGND VPWR _0723_/X _0723_/B _0723_/A _0723_/C VPWR VGND sky130_fd_sc_hd__and3_1
X_0585_ VPWR VGND VGND VPWR _0585_/A _0585_/SLEEP _0585_/X sky130_fd_sc_hd__lpflow_isobufsrc_1
X_0654_ VPWR VGND VGND VPWR _0654_/A _0654_/B _0654_/Y sky130_fd_sc_hd__nor2_1
X_1137_ VPWR VGND VGND VPWR _1137_/A _1137_/B _1137_/Y sky130_fd_sc_hd__nor2_1
X_1206_ VGND VPWR VPWR VGND _1206_/CLK _1206_/D _1206_/RESET_B _1206_/Q sky130_fd_sc_hd__dfrtp_1
X_1068_ VPWR VGND VGND VPWR _1068_/A _1068_/Y _1068_/B sky130_fd_sc_hd__nand2_1
Xclkbuf_4_4_0_clk VGND VPWR clkbuf_4_4_0_clk/A clkbuf_4_4_0_clk/X VPWR VGND sky130_fd_sc_hd__clkbuf_2
X_0706_ VGND VPWR VPWR VGND _0706_/C2 _0706_/C1 _0706_/B1 _0706_/A2 _0706_/A1 _0706_/Y
+ _0706_/B2 sky130_fd_sc_hd__a222oi_1
X_0637_ VPWR VGND VPWR VGND _0637_/B _0637_/D _0637_/C _0637_/A _0637_/X sky130_fd_sc_hd__or4_1
X_0971_ VPWR VGND VGND VPWR _0971_/A _0971_/Y _0971_/B sky130_fd_sc_hd__nand2_1
XPHY_30 VPWR VGND VPWR VGND sky130_fd_sc_hd__decap_3
XPHY_74 VPWR VGND VPWR VGND sky130_fd_sc_hd__decap_3
XPHY_63 VPWR VGND VPWR VGND sky130_fd_sc_hd__decap_3
XPHY_52 VPWR VGND VPWR VGND sky130_fd_sc_hd__decap_3
XPHY_41 VPWR VGND VPWR VGND sky130_fd_sc_hd__decap_3
X_1170_ VPWR VGND VPWR VGND _1170_/Q _1170_/SET_B _1170_/D _1170_/CLK sky130_fd_sc_hd__dfstp_2
X_0954_ VGND VPWR VGND VPWR _0954_/B1 _0954_/A1 _0954_/Y _0954_/A2 sky130_fd_sc_hd__o21ai_0
X_0885_ VGND VPWR VGND VPWR _0885_/B1 _0885_/A1 _0885_/Y _0885_/A2 sky130_fd_sc_hd__o21ai_0
X_1299_ VGND VPWR VPWR VGND _1299_/CLK _1299_/D _1299_/RESET_B _1299_/Q sky130_fd_sc_hd__dfrtp_1
X_0670_ VPWR VGND VGND VPWR _0670_/A _0670_/Y _0670_/B sky130_fd_sc_hd__nand2_1
X_1153_ VPWR VGND VPWR VGND _1153_/A2 _1153_/A1 _1153_/B1 _1153_/Y sky130_fd_sc_hd__a21oi_1
X_1222_ VGND VPWR VPWR VGND _1222_/CLK _1222_/D _1222_/RESET_B _1222_/Q sky130_fd_sc_hd__dfrtp_1
X_1084_ VPWR VGND VGND VPWR _1084_/A _1084_/Y _1084_/B sky130_fd_sc_hd__nand2_1
X_0799_ VPWR VGND VGND VPWR _0799_/A _0799_/B _0799_/Y sky130_fd_sc_hd__nor2_1
X_0868_ VPWR VGND VGND VPWR _0868_/A _0868_/Y _0868_/B sky130_fd_sc_hd__nand2_1
X_0937_ VPWR VGND VGND VPWR _0937_/A _0937_/Y _0937_/B sky130_fd_sc_hd__nand2_1
X_0653_ VPWR VGND VPWR VGND _0653_/B2 _0653_/B1 _0653_/Y _0653_/A1 _0653_/A2 sky130_fd_sc_hd__a22oi_1
X_0722_ VGND VPWR VPWR VGND _0722_/C2 _0722_/C1 _0722_/B1 _0722_/A2 _0722_/A1 _0722_/Y
+ _0722_/B2 sky130_fd_sc_hd__a222oi_1
X_0584_ VPWR VGND VGND VPWR _0584_/A _0584_/Y sky130_fd_sc_hd__clkinv_1
X_1136_ VPWR VGND VGND VPWR _1136_/A _1136_/Y _1136_/B sky130_fd_sc_hd__nand2_1
X_1205_ VGND VPWR VPWR VGND _1205_/CLK _1205_/D _1205_/RESET_B _1205_/Q sky130_fd_sc_hd__dfrtp_1
X_1067_ VPWR VGND VGND VPWR _1067_/A _1067_/Y _1067_/B sky130_fd_sc_hd__nand2_1
X_0636_ VGND VPWR VPWR VGND _0636_/A1 _0636_/A2 _0636_/B1_N _0636_/Y sky130_fd_sc_hd__a21boi_0
X_0705_ VPWR VGND VPWR VGND _0705_/B2 _0705_/B1 _0705_/Y _0705_/A1 _0705_/A2 sky130_fd_sc_hd__a22oi_1
X_1119_ VGND VPWR VGND VPWR _1119_/B1 _1119_/A1 _1119_/Y _1119_/A2 sky130_fd_sc_hd__o21ai_0
X_0619_ VGND VPWR VPWR VGND _0619_/X _0619_/A3 _0619_/A2 _0619_/A1 _0619_/B1 _0619_/B2
+ sky130_fd_sc_hd__a32o_1
Xclkbuf_4_3_0_clk VGND VPWR clkbuf_4_3_0_clk/A clkbuf_4_3_0_clk/X VPWR VGND sky130_fd_sc_hd__clkbuf_2
X_0970_ VPWR VGND VGND VPWR _0970_/A _0970_/Y _0970_/B sky130_fd_sc_hd__nand2_1
XPHY_64 VPWR VGND VPWR VGND sky130_fd_sc_hd__decap_3
XPHY_53 VPWR VGND VPWR VGND sky130_fd_sc_hd__decap_3
XPHY_20 VPWR VGND VPWR VGND sky130_fd_sc_hd__decap_3
XPHY_31 VPWR VGND VPWR VGND sky130_fd_sc_hd__decap_3
XPHY_42 VPWR VGND VPWR VGND sky130_fd_sc_hd__decap_3
XPHY_75 VPWR VGND VPWR VGND sky130_fd_sc_hd__decap_3
X_0953_ VPWR VGND VGND VPWR _0953_/A _0953_/Y _0953_/B sky130_fd_sc_hd__nand2_1
X_0884_ VPWR VGND VGND VPWR _0884_/A _0884_/Y _0884_/B sky130_fd_sc_hd__nand2_1
X_1298_ _1298_/Q _1298_/CLK _1298_/D VPWR VGND VPWR VGND sky130_fd_sc_hd__dfxtp_1
X_1221_ VGND VPWR VPWR VGND _1221_/CLK _1221_/D _1221_/RESET_B _1221_/Q sky130_fd_sc_hd__dfrtp_1
X_1152_ VPWR VGND VGND VPWR _1152_/A1 _1152_/A2 _1152_/B1 _1152_/B2 _1152_/Y sky130_fd_sc_hd__o22ai_1
X_1083_ VGND VPWR VGND VPWR _1083_/B1 _1083_/A1 _1083_/Y _1083_/A2 sky130_fd_sc_hd__o21ai_0
X_0936_ VPWR VGND VGND VPWR _0936_/A _0936_/Y _0936_/B sky130_fd_sc_hd__nand2_1
X_0798_ VGND VPWR VPWR VGND _0798_/X _0798_/B _0798_/A sky130_fd_sc_hd__and2_0
X_0867_ VGND VPWR VGND VPWR _0867_/B1 _0867_/A1 _0867_/Y _0867_/A2 sky130_fd_sc_hd__o21ai_0
X_0652_ VGND VPWR VGND VPWR _0652_/B1 _0652_/A1 _0652_/Y _0652_/A2 sky130_fd_sc_hd__o21ai_0
X_0583_ VPWR VGND VGND VPWR _0583_/A _0583_/Y sky130_fd_sc_hd__clkinv_1
X_0721_ VGND VPWR VPWR VGND _0721_/C2 _0721_/C1 _0721_/B1 _0721_/A2 _0721_/A1 _0721_/Y
+ _0721_/B2 sky130_fd_sc_hd__a222oi_1
X_1204_ VGND VPWR VPWR VGND _1204_/CLK _1204_/D _1204_/RESET_B _1204_/Q sky130_fd_sc_hd__dfrtp_1
X_1135_ VPWR VGND VGND VPWR _1135_/B2 _1135_/A2 _1135_/A1 _1135_/B1 _1135_/X sky130_fd_sc_hd__o22a_1
X_1066_ VPWR VGND VGND VPWR _1066_/A _1066_/Y _1066_/B sky130_fd_sc_hd__nand2_1
X_0919_ VPWR VGND VGND VPWR _0919_/A _0919_/Y _0919_/B sky130_fd_sc_hd__nand2_1
X_0635_ VPWR VGND VGND VPWR _0635_/A _0635_/B _0635_/Y sky130_fd_sc_hd__nor2_1
X_0704_ VPWR VGND VPWR VGND _0704_/B2 _0704_/B1 _0704_/Y _0704_/A1 _0704_/A2 sky130_fd_sc_hd__a22oi_1
X_1118_ VPWR VGND VGND VPWR _1118_/A _1118_/Y _1118_/B sky130_fd_sc_hd__nand2_1
X_1049_ VPWR VGND VGND VPWR _1049_/A _1049_/Y _1049_/B sky130_fd_sc_hd__nand2_1
X_0618_ VPWR VGND VPWR VGND _0618_/A1 _0618_/A2 _0618_/X _0618_/B1 _0618_/B2 _0618_/C1
+ sky130_fd_sc_hd__a221o_1
XPHY_76 VPWR VGND VPWR VGND sky130_fd_sc_hd__decap_3
XPHY_65 VPWR VGND VPWR VGND sky130_fd_sc_hd__decap_3
XPHY_54 VPWR VGND VPWR VGND sky130_fd_sc_hd__decap_3
XPHY_10 VPWR VGND VPWR VGND sky130_fd_sc_hd__decap_3
XPHY_21 VPWR VGND VPWR VGND sky130_fd_sc_hd__decap_3
XPHY_32 VPWR VGND VPWR VGND sky130_fd_sc_hd__decap_3
XPHY_43 VPWR VGND VPWR VGND sky130_fd_sc_hd__decap_3
X_0952_ VPWR VGND VGND VPWR _0952_/A _0952_/Y _0952_/B sky130_fd_sc_hd__nand2_1
X_0883_ VPWR VGND VGND VPWR _0883_/A _0883_/Y _0883_/B sky130_fd_sc_hd__nand2_1
X_1297_ _1297_/Q _1297_/CLK _1297_/D VPWR VGND VPWR VGND sky130_fd_sc_hd__dfxtp_1
Xclkbuf_4_2_0_clk VGND VPWR clkbuf_4_2_0_clk/A clkbuf_4_2_0_clk/X VPWR VGND sky130_fd_sc_hd__clkbuf_2
X_1151_ VPWR VGND VGND VPWR _1151_/C _1151_/B _1151_/A _1151_/Y sky130_fd_sc_hd__nor3_1
X_1220_ VGND VPWR VPWR VGND _1220_/CLK _1220_/D _1220_/RESET_B _1220_/Q sky130_fd_sc_hd__dfrtp_1
X_1082_ VPWR VGND VGND VPWR _1082_/A _1082_/Y _1082_/B sky130_fd_sc_hd__nand2_1
X_0866_ VPWR VGND VGND VPWR _0866_/A _0866_/Y _0866_/B sky130_fd_sc_hd__nand2_1
X_0935_ VPWR VGND VGND VPWR _0935_/A _0935_/Y _0935_/B sky130_fd_sc_hd__nand2_1
X_0797_ VPWR VGND VPWR VGND _0797_/B1 _0797_/A1 _0797_/A2 _0797_/X _0797_/B2 sky130_fd_sc_hd__a22o_1
X_0720_ VPWR VGND VPWR VGND _0720_/B2 _0720_/B1 _0720_/Y _0720_/A1 _0720_/A2 sky130_fd_sc_hd__a22oi_1
X_0582_ VPWR VGND VGND VPWR _0582_/A _0582_/Y sky130_fd_sc_hd__clkinv_1
X_0651_ VPWR VGND VGND VPWR _0651_/A _0651_/Y _0651_/B sky130_fd_sc_hd__nand2_1
X_1134_ VPWR VGND VPWR VGND _1134_/B _1134_/C _1134_/A _1134_/X sky130_fd_sc_hd__or3_1
X_1203_ VGND VPWR VPWR VGND _1203_/CLK _1203_/D _1203_/RESET_B _1203_/Q sky130_fd_sc_hd__dfrtp_1
X_1065_ VGND VPWR VGND VPWR _1065_/B1 _1065_/A1 _1065_/Y _1065_/A2 sky130_fd_sc_hd__o21ai_0
X_0849_ VPWR VGND _0849_/A1 _0849_/A2 _0849_/A3 _0849_/Y _0849_/B1 VPWR VGND sky130_fd_sc_hd__o31ai_1
X_0918_ VGND VPWR VGND VPWR _0918_/B1 _0918_/A1 _0918_/Y _0918_/A2 sky130_fd_sc_hd__o21ai_0
X_0703_ VPWR VGND VGND VPWR _0703_/A _0703_/B _0703_/Y sky130_fd_sc_hd__nor2_1
X_0634_ VPWR VGND VPWR VGND _0634_/B _0634_/D _0634_/C _0634_/A _0634_/X sky130_fd_sc_hd__or4_1
X_1117_ VPWR VGND VGND VPWR _1117_/A _1117_/Y _1117_/B sky130_fd_sc_hd__nand2_1
X_1048_ VPWR VGND VGND VPWR _1048_/A _1048_/Y _1048_/B sky130_fd_sc_hd__nand2_1
X_0617_ VPWR VGND VGND VPWR _0617_/C _0617_/B _0617_/A _0617_/Y sky130_fd_sc_hd__nor3_1
XPHY_77 VPWR VGND VPWR VGND sky130_fd_sc_hd__decap_3
XPHY_66 VPWR VGND VPWR VGND sky130_fd_sc_hd__decap_3
XPHY_55 VPWR VGND VPWR VGND sky130_fd_sc_hd__decap_3
XPHY_11 VPWR VGND VPWR VGND sky130_fd_sc_hd__decap_3
XPHY_22 VPWR VGND VPWR VGND sky130_fd_sc_hd__decap_3
XPHY_33 VPWR VGND VPWR VGND sky130_fd_sc_hd__decap_3
XPHY_44 VPWR VGND VPWR VGND sky130_fd_sc_hd__decap_3
X_0951_ VPWR VGND VGND VPWR _0951_/A _0951_/Y _0951_/B sky130_fd_sc_hd__nand2_1
X_0882_ VGND VPWR VGND VPWR _0882_/B1 _0882_/A1 _0882_/Y _0882_/A2 sky130_fd_sc_hd__o21ai_0
X_1296_ _1296_/Q _1296_/CLK _1296_/D VPWR VGND VPWR VGND sky130_fd_sc_hd__dfxtp_1
X_1150_ VPWR VGND VGND VPWR _1150_/A _1150_/B _1150_/Y sky130_fd_sc_hd__nor2_1
X_1081_ VPWR VGND VGND VPWR _1081_/A _1081_/Y _1081_/B sky130_fd_sc_hd__nand2_1
X_0865_ VPWR VGND VGND VPWR _0865_/A _0865_/Y _0865_/B sky130_fd_sc_hd__nand2_1
X_0934_ VPWR VGND VGND VPWR _0934_/A _0934_/Y _0934_/B sky130_fd_sc_hd__nand2_1
X_0796_ VPWR VGND VGND VPWR _0796_/C _0796_/B _0796_/A _0796_/Y sky130_fd_sc_hd__nor3_1
X_1279_ VGND VPWR VPWR VGND _1279_/CLK _1279_/D _1279_/RESET_B _1279_/Q sky130_fd_sc_hd__dfrtp_1
X_0581_ VPWR VGND VGND VPWR _0581_/A _0581_/Y sky130_fd_sc_hd__clkinv_1
X_0650_ VPWR VGND VGND VPWR _0650_/A _0650_/B _0650_/Y _0650_/C sky130_fd_sc_hd__nand3_1
X_1133_ VGND VPWR VGND VPWR _1133_/B1 _1133_/A1 _1133_/Y _1133_/A2 sky130_fd_sc_hd__o21ai_0
X_1202_ VGND VPWR VPWR VGND _1202_/CLK _1202_/D _1202_/RESET_B _1202_/Q sky130_fd_sc_hd__dfrtp_1
Xclkbuf_4_1_0_clk VGND VPWR clkbuf_4_1_0_clk/A clkbuf_4_1_0_clk/X VPWR VGND sky130_fd_sc_hd__clkbuf_2
X_1064_ VPWR VGND VGND VPWR _1064_/A _1064_/Y _1064_/B sky130_fd_sc_hd__nand2_1
X_0779_ VPWR VGND VGND VPWR _0779_/A _0779_/Y _0779_/B sky130_fd_sc_hd__nand2_1
X_0848_ VPWR VGND VGND VPWR _0848_/A _0848_/Y _0848_/B sky130_fd_sc_hd__nand2_1
X_0917_ VPWR VGND VGND VPWR _0917_/A _0917_/Y _0917_/B sky130_fd_sc_hd__nand2_1
X_0633_ VPWR VGND VGND VPWR _0633_/A _0633_/B _0633_/Y sky130_fd_sc_hd__nor2_1
X_0702_ VGND VPWR VPWR VGND _0702_/Y _0702_/B1 _0702_/C1 _0702_/A1 _0702_/A2 _0702_/B2
+ sky130_fd_sc_hd__a221oi_1
X_1047_ VGND VPWR VGND VPWR _1047_/B1 _1047_/A1 _1047_/Y _1047_/A2 sky130_fd_sc_hd__o21ai_0
X_1116_ VPWR VGND VGND VPWR _1116_/A _1116_/Y _1116_/B sky130_fd_sc_hd__nand2_1
X_0616_ VPWR VGND VGND VPWR _0616_/A _0616_/B _0616_/Y sky130_fd_sc_hd__nor2_1
XPHY_12 VPWR VGND VPWR VGND sky130_fd_sc_hd__decap_3
XPHY_67 VPWR VGND VPWR VGND sky130_fd_sc_hd__decap_3
XPHY_56 VPWR VGND VPWR VGND sky130_fd_sc_hd__decap_3
XPHY_23 VPWR VGND VPWR VGND sky130_fd_sc_hd__decap_3
XPHY_34 VPWR VGND VPWR VGND sky130_fd_sc_hd__decap_3
XPHY_45 VPWR VGND VPWR VGND sky130_fd_sc_hd__decap_3
X_0950_ VPWR VGND VGND VPWR _0950_/A _0950_/Y _0950_/B sky130_fd_sc_hd__nand2_1
X_0881_ VPWR VGND VGND VPWR _0881_/A _0881_/Y _0881_/B sky130_fd_sc_hd__nand2_1
X_1295_ _1295_/Q _1295_/CLK _1295_/D VPWR VGND VPWR VGND sky130_fd_sc_hd__dfxtp_1
X_1080_ VPWR VGND VGND VPWR _1080_/A _1080_/Y _1080_/B sky130_fd_sc_hd__nand2_1
X_0795_ VPWR VGND VGND VPWR _0795_/A _0795_/Y _0795_/B sky130_fd_sc_hd__nand2_1
X_0864_ VGND VPWR VGND VPWR _0864_/B1 _0864_/A1 _0864_/Y _0864_/A2 sky130_fd_sc_hd__o21ai_0
X_0933_ VPWR VGND VGND VPWR _0933_/A _0933_/Y _0933_/B sky130_fd_sc_hd__nand2_1
X_1278_ VGND VPWR VPWR VGND _1278_/CLK _1278_/D _1278_/RESET_B _1278_/Q sky130_fd_sc_hd__dfrtp_1
X_0580_ VPWR VGND VGND VPWR _0580_/A _0580_/Y sky130_fd_sc_hd__clkinv_1
X_1201_ VGND VPWR VPWR VGND _1201_/CLK _1201_/D _1201_/RESET_B _1201_/Q sky130_fd_sc_hd__dfrtp_1
X_1132_ VPWR VGND VPWR VGND _1132_/A2 _1132_/A1 _1132_/B1 _1132_/Y sky130_fd_sc_hd__a21oi_1
X_1063_ VPWR VGND VGND VPWR _1063_/A _1063_/Y _1063_/B sky130_fd_sc_hd__nand2_1
X_0916_ VPWR VGND VGND VPWR _0916_/A _0916_/Y _0916_/B sky130_fd_sc_hd__nand2_1
X_0778_ VPWR VGND VPWR VGND _0778_/A2 _0778_/A1 _0778_/B1 _0778_/Y sky130_fd_sc_hd__a21oi_1
X_0847_ VPWR VGND VPWR VGND _0847_/A2 _0847_/A1 _0847_/B1 _0847_/Y sky130_fd_sc_hd__a21oi_1
X_0632_ VGND VPWR _0632_/B _0632_/Y _0632_/A VPWR VGND sky130_fd_sc_hd__xnor2_1
X_0701_ VPWR VGND VPWR VGND _0701_/A _0701_/C _0701_/D _0701_/Y _0701_/B sky130_fd_sc_hd__nand4_1
X_1046_ VPWR VGND VGND VPWR _1046_/A _1046_/Y _1046_/B sky130_fd_sc_hd__nand2_1
X_1115_ VPWR VGND VGND VPWR _1115_/A _1115_/Y _1115_/B sky130_fd_sc_hd__nand2_1
Xclkbuf_4_0_0_clk VGND VPWR clkbuf_4_0_0_clk/A clkbuf_4_0_0_clk/X VPWR VGND sky130_fd_sc_hd__clkbuf_2
X_0615_ VPWR VGND VPWR VGND _0615_/A2 _0615_/A1 _0615_/B1 _0615_/X sky130_fd_sc_hd__a21o_1
X_1029_ VPWR VGND VGND VPWR _1029_/A _1029_/Y _1029_/B sky130_fd_sc_hd__nand2_1
XPHY_46 VPWR VGND VPWR VGND sky130_fd_sc_hd__decap_3
XPHY_13 VPWR VGND VPWR VGND sky130_fd_sc_hd__decap_3
XPHY_24 VPWR VGND VPWR VGND sky130_fd_sc_hd__decap_3
XPHY_35 VPWR VGND VPWR VGND sky130_fd_sc_hd__decap_3
XPHY_68 VPWR VGND VPWR VGND sky130_fd_sc_hd__decap_3
XPHY_57 VPWR VGND VPWR VGND sky130_fd_sc_hd__decap_3
X_0880_ VPWR VGND VGND VPWR _0880_/A _0880_/Y _0880_/B sky130_fd_sc_hd__nand2_1
X_1294_ VGND VPWR VPWR VGND _1294_/CLK _1294_/D _1294_/RESET_B _1294_/Q sky130_fd_sc_hd__dfrtp_1
X_0932_ VPWR VGND VGND VPWR _0932_/A _0932_/Y _0932_/B sky130_fd_sc_hd__nand2_1
X_0794_ VGND VPWR VGND VPWR _0794_/B1 _0794_/A1 _0794_/Y _0794_/A2 sky130_fd_sc_hd__o21ai_0
X_0863_ VPWR VGND VGND VPWR _0863_/A _0863_/Y _0863_/B sky130_fd_sc_hd__nand2_1
X_1277_ VGND VPWR VPWR VGND _1277_/CLK _1277_/D _1277_/RESET_B _1277_/Q sky130_fd_sc_hd__dfrtp_1
X_1200_ VGND VPWR VPWR VGND _1200_/CLK _1200_/D _1200_/RESET_B _1200_/Q sky130_fd_sc_hd__dfrtp_1
X_1131_ VGND VPWR VGND VPWR _1131_/B1 _1131_/A1 _1131_/Y _1131_/A2 sky130_fd_sc_hd__o21ai_0
X_1062_ VPWR VGND VGND VPWR _1062_/A _1062_/Y _1062_/B sky130_fd_sc_hd__nand2_1
X_0915_ VGND VPWR VGND VPWR _0915_/B1 _0915_/A1 _0915_/Y _0915_/A2 sky130_fd_sc_hd__o21ai_0
X_0777_ VGND VPWR VGND VPWR _0777_/B1 _0777_/A1 _0777_/Y _0777_/A2 sky130_fd_sc_hd__o21ai_0
X_0846_ VPWR VGND VGND VPWR _0846_/C _0846_/B _0846_/A _0846_/Y sky130_fd_sc_hd__nor3_1
X_0700_ VGND VPWR VPWR VGND _0700_/C2 _0700_/C1 _0700_/B1 _0700_/A2 _0700_/A1 _0700_/Y
+ _0700_/B2 sky130_fd_sc_hd__a222oi_1
X_0631_ VGND VPWR VPWR VGND _0631_/A _0631_/X _0631_/B sky130_fd_sc_hd__xor2_1
X_1114_ VPWR VGND VGND VPWR _1114_/A _1114_/Y _1114_/B sky130_fd_sc_hd__nand2_1
X_1045_ VPWR VGND VGND VPWR _1045_/A _1045_/Y _1045_/B sky130_fd_sc_hd__nand2_1
X_0829_ VPWR VGND VPWR VGND _0829_/A _0829_/C _0829_/D _0829_/Y _0829_/B sky130_fd_sc_hd__nand4_1
X_0614_ VPWR VGND VGND VPWR _0614_/A_N _0614_/B _0614_/Y sky130_fd_sc_hd__nand2b_1
X_1028_ VPWR VGND VGND VPWR _1028_/A _1028_/Y _1028_/B sky130_fd_sc_hd__nand2_1
XPHY_69 VPWR VGND VPWR VGND sky130_fd_sc_hd__decap_3
XPHY_58 VPWR VGND VPWR VGND sky130_fd_sc_hd__decap_3
XPHY_47 VPWR VGND VPWR VGND sky130_fd_sc_hd__decap_3
XPHY_14 VPWR VGND VPWR VGND sky130_fd_sc_hd__decap_3
XPHY_25 VPWR VGND VPWR VGND sky130_fd_sc_hd__decap_3
XPHY_36 VPWR VGND VPWR VGND sky130_fd_sc_hd__decap_3
X_1293_ VGND VPWR VPWR VGND _1293_/CLK _1293_/D _1293_/RESET_B _1293_/Q sky130_fd_sc_hd__dfrtp_1
X_0862_ VPWR VGND VGND VPWR _0862_/A _0862_/Y _0862_/B sky130_fd_sc_hd__nand2_1
X_0931_ VPWR VGND VGND VPWR _0931_/A _0931_/Y _0931_/B sky130_fd_sc_hd__nand2_1
X_0793_ VPWR VGND VGND VPWR _0793_/A _0793_/Y _0793_/B sky130_fd_sc_hd__nand2_1
X_1276_ VGND VPWR VPWR VGND _1276_/CLK _1276_/D _1276_/RESET_B _1276_/Q sky130_fd_sc_hd__dfrtp_1
X_1130_ VPWR VGND VGND VPWR _1130_/A _1130_/Y _1130_/B sky130_fd_sc_hd__nand2_1
X_1061_ VPWR VGND VGND VPWR _1061_/A _1061_/Y _1061_/B sky130_fd_sc_hd__nand2_1
X_0914_ VPWR VGND VGND VPWR _0914_/A _0914_/Y _0914_/B sky130_fd_sc_hd__nand2_1
X_0845_ VPWR VGND VGND VPWR _0845_/Y _0845_/D _0845_/C _0845_/B _0845_/A sky130_fd_sc_hd__nor4_1
X_0776_ VPWR VGND VGND VPWR _0776_/A _0776_/B _0776_/Y sky130_fd_sc_hd__nor2_1
X_1259_ VGND VPWR VPWR VGND _1259_/CLK _1259_/D _1259_/RESET_B _1259_/Q sky130_fd_sc_hd__dfrtp_1
X_0630_ VGND VPWR VPWR VGND _0630_/X _0630_/B _0630_/A sky130_fd_sc_hd__and2_0
X_1044_ VPWR VGND VGND VPWR _1044_/A _1044_/Y _1044_/B sky130_fd_sc_hd__nand2_1
X_1113_ VGND VPWR VGND VPWR _1113_/B1 _1113_/A1 _1113_/Y _1113_/A2 sky130_fd_sc_hd__o21ai_0
X_0759_ VPWR VGND VPWR VGND _0759_/A2 _0759_/A1 _0759_/B1 _0759_/Y sky130_fd_sc_hd__a21oi_1
X_0828_ VPWR VGND VGND VPWR _0828_/A _0828_/Y _0828_/B sky130_fd_sc_hd__nand2_1
X_0613_ VPWR VGND VGND VPWR _0613_/A _0613_/SLEEP _0613_/X sky130_fd_sc_hd__lpflow_isobufsrc_1
X_1027_ VPWR VGND VGND VPWR _1027_/A _1027_/Y _1027_/B sky130_fd_sc_hd__nand2_1
XPHY_59 VPWR VGND VPWR VGND sky130_fd_sc_hd__decap_3
XPHY_48 VPWR VGND VPWR VGND sky130_fd_sc_hd__decap_3
XPHY_15 VPWR VGND VPWR VGND sky130_fd_sc_hd__decap_3
XPHY_26 VPWR VGND VPWR VGND sky130_fd_sc_hd__decap_3
XPHY_37 VPWR VGND VPWR VGND sky130_fd_sc_hd__decap_3
X_1292_ VGND VPWR VPWR VGND _1292_/CLK _1292_/D _1292_/RESET_B _1292_/Q sky130_fd_sc_hd__dfrtp_1
X_0792_ VPWR VGND _0792_/A1 _0792_/A2 _0792_/A3 _0792_/Y _0792_/B1 VPWR VGND sky130_fd_sc_hd__o31ai_1
X_0861_ VGND VPWR VGND VPWR _0861_/B1 _0861_/A1 _0861_/Y _0861_/A2 sky130_fd_sc_hd__o21ai_0
X_0930_ VPWR VGND VGND VPWR _0930_/A _0930_/Y _0930_/B sky130_fd_sc_hd__nand2_1
X_1275_ VGND VPWR VPWR VGND _1275_/CLK _1275_/D _1275_/RESET_B _1275_/Q sky130_fd_sc_hd__dfrtp_1
X_1060_ VPWR VGND VGND VPWR _1060_/A _1060_/Y _1060_/B sky130_fd_sc_hd__nand2_1
X_0775_ VPWR VGND VGND VPWR _0775_/A _0775_/Y _0775_/B sky130_fd_sc_hd__nand2_1
X_0913_ VPWR VGND VGND VPWR _0913_/A _0913_/Y _0913_/B sky130_fd_sc_hd__nand2_1
X_0844_ VPWR VGND VPWR VGND _0844_/B _0844_/D _0844_/C _0844_/A _0844_/X sky130_fd_sc_hd__or4_1
X_1189_ _1189_/Q _1189_/CLK _1189_/D VPWR VGND VPWR VGND sky130_fd_sc_hd__dfxtp_1
X_1258_ VGND VPWR VPWR VGND _1258_/CLK _1258_/D _1258_/RESET_B _1258_/Q sky130_fd_sc_hd__dfrtp_1
X_1043_ VPWR VGND VGND VPWR _1043_/A _1043_/Y _1043_/B sky130_fd_sc_hd__nand2_1
X_1112_ VPWR VGND VGND VPWR _1112_/A _1112_/Y _1112_/B sky130_fd_sc_hd__nand2_1
X_0758_ VGND VPWR _0758_/B _0758_/Y _0758_/A VPWR VGND sky130_fd_sc_hd__xnor2_1
X_0827_ VPWR VGND VGND VPWR _0827_/A _0827_/B _0827_/Y sky130_fd_sc_hd__nor2_1
X_0689_ VPWR VGND VGND VPWR _0689_/A _0689_/B _0689_/Y sky130_fd_sc_hd__nor2_1
X_0612_ VPWR VGND VGND VPWR _0612_/C _0612_/B _0612_/A _0612_/Y sky130_fd_sc_hd__nor3_1
X_1026_ VGND VPWR VGND VPWR _1026_/B1 _1026_/A1 _1026_/Y _1026_/A2 sky130_fd_sc_hd__o21ai_0
XPHY_49 VPWR VGND VPWR VGND sky130_fd_sc_hd__decap_3
XPHY_16 VPWR VGND VPWR VGND sky130_fd_sc_hd__decap_3
XPHY_27 VPWR VGND VPWR VGND sky130_fd_sc_hd__decap_3
X_1009_ VPWR VGND VGND VPWR _1009_/A _1009_/Y _1009_/B sky130_fd_sc_hd__nand2_1
XPHY_38 VPWR VGND VPWR VGND sky130_fd_sc_hd__decap_3
X_1291_ VGND VPWR VPWR VGND _1291_/CLK _1291_/D _1291_/RESET_B _1291_/Q sky130_fd_sc_hd__dfrtp_1
X_0791_ VGND VPWR _0791_/X _0791_/B _0791_/A _0791_/C VPWR VGND sky130_fd_sc_hd__and3_1
X_0860_ VPWR VGND VGND VPWR _0860_/A _0860_/Y _0860_/B sky130_fd_sc_hd__nand2_1
X_1274_ VGND VPWR VPWR VGND _1274_/CLK _1274_/D _1274_/RESET_B _1274_/Q sky130_fd_sc_hd__dfrtp_1
X_0989_ VPWR VGND VGND VPWR _0989_/A _0989_/Y _0989_/B sky130_fd_sc_hd__nand2_1
X_0912_ VGND VPWR VGND VPWR _0912_/B1 _0912_/A1 _0912_/Y _0912_/A2 sky130_fd_sc_hd__o21ai_0
X_0774_ VPWR VGND VPWR VGND _0774_/B1 _0774_/A1 _0774_/A2 _0774_/X _0774_/B2 sky130_fd_sc_hd__a22o_1
X_0843_ VPWR VGND VPWR VGND _0843_/A _0843_/C _0843_/D _0843_/Y _0843_/B sky130_fd_sc_hd__nand4_1
X_1188_ _1188_/Q _1188_/CLK _1188_/D VPWR VGND VPWR VGND sky130_fd_sc_hd__dfxtp_1
X_1257_ VGND VPWR VPWR VGND _1257_/CLK _1257_/D _1257_/RESET_B _1257_/Q sky130_fd_sc_hd__dfrtp_1
X_1042_ VPWR VGND VGND VPWR _1042_/A _1042_/Y _1042_/B sky130_fd_sc_hd__nand2_1
X_1111_ VPWR VGND VGND VPWR _1111_/A _1111_/Y _1111_/B sky130_fd_sc_hd__nand2_1
X_0688_ VPWR VGND VGND VPWR _0688_/Y _0688_/D _0688_/C _0688_/B _0688_/A sky130_fd_sc_hd__nor4_1
X_0757_ VPWR VGND VGND VPWR _0757_/A _0757_/B _0757_/Y _0757_/C sky130_fd_sc_hd__nand3_1
X_0826_ VPWR VGND VGND VPWR _0826_/A _0826_/B _0826_/Y _0826_/C sky130_fd_sc_hd__nand3_1
Xclkbuf_4_15_0_clk VGND VPWR clkbuf_4_15_0_clk/A clkbuf_4_15_0_clk/X VPWR VGND sky130_fd_sc_hd__clkbuf_2
X_1309_ VGND VPWR VPWR VGND _1309_/CLK _1309_/D _1309_/RESET_B _1309_/Q sky130_fd_sc_hd__dfrtp_1
X_0611_ VPWR VGND VGND VPWR _0611_/A _0611_/Y _0611_/B sky130_fd_sc_hd__nand2_1
X_1025_ VPWR VGND VGND VPWR _1025_/A _1025_/Y _1025_/B sky130_fd_sc_hd__nand2_1
X_0809_ VPWR VGND VGND VPWR _0809_/A _0809_/B _0809_/Y sky130_fd_sc_hd__nor2_1
XPHY_17 VPWR VGND VPWR VGND sky130_fd_sc_hd__decap_3
XPHY_28 VPWR VGND VPWR VGND sky130_fd_sc_hd__decap_3
X_1008_ VPWR VGND VGND VPWR _1008_/A _1008_/Y _1008_/B sky130_fd_sc_hd__nand2_1
XPHY_39 VPWR VGND VPWR VGND sky130_fd_sc_hd__decap_3
X_1290_ VGND VPWR VPWR VGND _1290_/CLK _1290_/D _1290_/RESET_B _1290_/Q sky130_fd_sc_hd__dfrtp_1
X_0790_ VPWR VGND VGND VPWR _0790_/A _0790_/Y _0790_/B sky130_fd_sc_hd__nand2_1
X_1273_ VGND VPWR VPWR VGND _1273_/CLK _1273_/D _1273_/RESET_B _1273_/Q sky130_fd_sc_hd__dfrtp_1
X_0988_ VPWR VGND VGND VPWR _0988_/A _0988_/Y _0988_/B sky130_fd_sc_hd__nand2_1
X_0911_ VPWR VGND VGND VPWR _0911_/A _0911_/Y _0911_/B sky130_fd_sc_hd__nand2_1
X_0842_ VPWR VGND VGND VPWR _0842_/A _0842_/SLEEP _0842_/X sky130_fd_sc_hd__lpflow_isobufsrc_1
X_0773_ VPWR VGND VGND VPWR _0773_/C _0773_/B _0773_/A _0773_/Y sky130_fd_sc_hd__nor3_1
X_1256_ VGND VPWR VPWR VGND _1256_/CLK _1256_/D _1256_/RESET_B _1256_/Q sky130_fd_sc_hd__dfrtp_1
X_1187_ _1187_/Q _1187_/CLK _1187_/D VPWR VGND VPWR VGND sky130_fd_sc_hd__dfxtp_1
X_1110_ VPWR VGND VGND VPWR _1110_/A _1110_/Y _1110_/B sky130_fd_sc_hd__nand2_1
X_1041_ VGND VPWR VGND VPWR _1041_/B1 _1041_/A1 _1041_/Y _1041_/A2 sky130_fd_sc_hd__o21ai_0
X_0825_ VPWR VGND VGND VPWR _0825_/A _0825_/B _0825_/Y sky130_fd_sc_hd__nor2_1
X_0756_ VPWR VGND VGND VPWR _0756_/A _0756_/B _0756_/Y _0756_/C sky130_fd_sc_hd__nand3_1
X_0687_ VPWR VGND VGND VPWR _0687_/A _0687_/B _0687_/Y sky130_fd_sc_hd__nor2_1
X_1308_ VGND VPWR VPWR VGND _1308_/CLK _1308_/D _1308_/RESET_B _1308_/Q sky130_fd_sc_hd__dfrtp_1
X_1239_ VGND VPWR VPWR VGND _1239_/CLK _1239_/D _1239_/RESET_B _1239_/Q sky130_fd_sc_hd__dfrtp_1
X_0610_ VPWR VGND VPWR VGND _0610_/A2 _0610_/A1 _0610_/B1 _0610_/X sky130_fd_sc_hd__a21o_1
X_1024_ VPWR VGND VGND VPWR _1024_/A _1024_/Y _1024_/B sky130_fd_sc_hd__nand2_1
X_0808_ VPWR VGND VPWR VGND _0808_/A _0808_/C _0808_/D _0808_/Y _0808_/B sky130_fd_sc_hd__nand4_1
X_0739_ VPWR VGND VPWR VGND _0739_/B2 _0739_/B1 _0739_/Y _0739_/A1 _0739_/A2 sky130_fd_sc_hd__a22oi_1
Xclkbuf_4_14_0_clk VGND VPWR clkbuf_4_14_0_clk/A clkbuf_4_14_0_clk/X VPWR VGND sky130_fd_sc_hd__clkbuf_2
XPHY_18 VPWR VGND VPWR VGND sky130_fd_sc_hd__decap_3
XPHY_29 VPWR VGND VPWR VGND sky130_fd_sc_hd__decap_3
X_1007_ VPWR VGND VGND VPWR _1007_/A _1007_/Y _1007_/B sky130_fd_sc_hd__nand2_1
X_1272_ VGND VPWR VPWR VGND _1272_/CLK _1272_/D _1272_/RESET_B _1272_/Q sky130_fd_sc_hd__dfrtp_1
X_0987_ VGND VPWR VGND VPWR _0987_/B1 _0987_/A1 _0987_/Y _0987_/A2 sky130_fd_sc_hd__o21ai_0
X_0772_ VPWR VGND VGND VPWR _0772_/A _0772_/B _0772_/Y sky130_fd_sc_hd__nor2_1
X_0910_ VPWR VGND VGND VPWR _0910_/A _0910_/Y _0910_/B sky130_fd_sc_hd__nand2_1
X_0841_ VPWR VGND VPWR VGND _0841_/A _0841_/C _0841_/D _0841_/Y _0841_/B sky130_fd_sc_hd__nand4_1
X_1186_ _1186_/Q _1186_/CLK _1186_/D VPWR VGND VPWR VGND sky130_fd_sc_hd__dfxtp_1
X_1255_ VGND VPWR VPWR VGND _1255_/CLK _1255_/D _1255_/RESET_B _1255_/Q sky130_fd_sc_hd__dfrtp_1
X_1040_ VPWR VGND VGND VPWR _1040_/A _1040_/Y _1040_/B sky130_fd_sc_hd__nand2_1
X_0755_ VPWR VGND VGND VPWR _0755_/A _0755_/SLEEP _0755_/X sky130_fd_sc_hd__lpflow_isobufsrc_1
X_0824_ VPWR VGND VGND VPWR _0824_/D_N _0824_/C _0824_/Y _0824_/B _0824_/A sky130_fd_sc_hd__nor4b_1
X_0686_ VPWR VGND VGND VPWR _0686_/A_N _0686_/B _0686_/Y sky130_fd_sc_hd__nand2b_1
X_1307_ VGND VPWR VPWR VGND _1307_/CLK _1307_/D _1307_/RESET_B _1307_/Q sky130_fd_sc_hd__dfrtp_1
X_1169_ VPWR VGND VPWR VGND _1169_/B _1169_/C _1169_/A _1169_/X sky130_fd_sc_hd__or3_1
X_1238_ VGND VPWR VPWR VGND _1238_/CLK _1238_/D _1238_/RESET_B _1238_/Q sky130_fd_sc_hd__dfrtp_1
X_1023_ VPWR VGND VGND VPWR _1023_/A _1023_/Y _1023_/B sky130_fd_sc_hd__nand2_1
X_0807_ VPWR VGND VGND VPWR _0807_/C _0807_/B _0807_/A _0807_/Y sky130_fd_sc_hd__nor3_1
X_0738_ VGND VPWR VPWR VGND _0738_/A3 _0738_/A2 _0738_/A1 _0738_/Y _0738_/B1 sky130_fd_sc_hd__a31oi_1
X_0669_ VPWR VGND VGND VPWR _0669_/A _0669_/B _0669_/Y sky130_fd_sc_hd__nor2_1
XPHY_19 VPWR VGND VPWR VGND sky130_fd_sc_hd__decap_3
X_1006_ VPWR VGND VGND VPWR _1006_/A _1006_/Y _1006_/B sky130_fd_sc_hd__nand2_1
Xclkbuf_4_13_0_clk VGND VPWR clkbuf_4_13_0_clk/A clkbuf_4_13_0_clk/X VPWR VGND sky130_fd_sc_hd__clkbuf_2
X_1271_ VGND VPWR VPWR VGND _1271_/CLK _1271_/D _1271_/RESET_B _1271_/Q sky130_fd_sc_hd__dfrtp_1
X_0986_ VPWR VGND VGND VPWR _0986_/A _0986_/Y _0986_/B sky130_fd_sc_hd__nand2_1
X_0771_ VPWR VGND VPWR VGND _0771_/A2 _0771_/A1 _0771_/B1 _0771_/Y sky130_fd_sc_hd__a21oi_1
X_0840_ VPWR VGND VGND VPWR _0840_/Y _0840_/D _0840_/C _0840_/B _0840_/A sky130_fd_sc_hd__nor4_1
X_1185_ _1185_/Q _1185_/CLK _1185_/D VPWR VGND VPWR VGND sky130_fd_sc_hd__dfxtp_1
X_1254_ VGND VPWR VPWR VGND _1254_/CLK _1254_/D _1254_/RESET_B _1254_/Q sky130_fd_sc_hd__dfrtp_1
X_0969_ VGND VPWR VGND VPWR _0969_/B1 _0969_/A1 _0969_/Y _0969_/A2 sky130_fd_sc_hd__o21ai_0
X_0685_ VPWR VGND VGND VPWR _0685_/A_N _0685_/B _0685_/Y sky130_fd_sc_hd__nand2b_1
X_0754_ VPWR VGND VGND VPWR _0754_/A _0754_/B _0754_/Y _0754_/C sky130_fd_sc_hd__nand3_1
X_0823_ VPWR VGND VGND VPWR _0823_/D_N _0823_/C _0823_/Y _0823_/B _0823_/A sky130_fd_sc_hd__nor4b_1
X_1306_ VGND VPWR VPWR VGND _1306_/CLK _1306_/D _1306_/RESET_B _1306_/Q sky130_fd_sc_hd__dfrtp_1
X_1168_ VPWR VGND VPWR VGND _1168_/A2 _1168_/A1 _1168_/B1 _1168_/X sky130_fd_sc_hd__a21o_1
X_1099_ VPWR VGND VGND VPWR _1099_/A _1099_/Y _1099_/B sky130_fd_sc_hd__nand2_1
X_1237_ VGND VPWR VPWR VGND _1237_/CLK _1237_/D _1237_/RESET_B _1237_/Q sky130_fd_sc_hd__dfrtp_1
X_1022_ VPWR VGND VGND VPWR _1022_/A _1022_/Y _1022_/B sky130_fd_sc_hd__nand2_1
X_0806_ VPWR VGND VGND VPWR _0806_/A _0806_/B _0806_/Y _0806_/C sky130_fd_sc_hd__nand3_1
X_0668_ VPWR VGND VGND VPWR _0668_/A _0668_/Y _0668_/B sky130_fd_sc_hd__nand2_1
X_0737_ VGND VPWR _0737_/X _0737_/B _0737_/A _0737_/C VPWR VGND sky130_fd_sc_hd__and3_1
X_0599_ VPWR VGND VPWR VGND _0599_/A2 _0599_/A1 _0599_/B1 _0599_/Y sky130_fd_sc_hd__a21oi_1
X_1005_ VPWR VGND VGND VPWR _1005_/A _1005_/Y _1005_/B sky130_fd_sc_hd__nand2_1
.ends
